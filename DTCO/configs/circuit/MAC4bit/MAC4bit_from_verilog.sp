* HSPICE netlist converted from synthesized Verilog: MAC4bit_m.v
* Top-level .SUBCKT name/ports kept identical to prior MAC4bit_from_verilog_corrected.sp for testbench reuse.
.GLOBAL VDD VSS
.SUBCKT MAC4bit a_0 a_1 a_2 a_3 b_0 b_1 b_2 b_3 c_0 c_1 c_2 c_3 c_4 c_5 c_6 c_7 out_0 out_1 out_2 out_3 out_4 out_5 out_6 out_7
XWALLACE_CSA_DUMMY_OP_groupi_g1209__8428 WALLACE_CSA_DUMMY_OP_groupi_n_163 WALLACE_CSA_DUMMY_OP_groupi_n_138 VDD VDD VSS VSS WALLACE_CSA_DUMMY_OP_groupi_n_166 NOR2V1_90S9T20R
XWALLACE_CSA_DUMMY_OP_groupi_g1212__3680 WALLACE_CSA_DUMMY_OP_groupi_n_161 WALLACE_CSA_DUMMY_OP_groupi_n_140 VDD VDD VSS VSS WALLACE_CSA_DUMMY_OP_groupi_n_163 NOR2V1_90S9T20R
XWALLACE_CSA_DUMMY_OP_groupi_g1214__2802 WALLACE_CSA_DUMMY_OP_groupi_n_159 WALLACE_CSA_DUMMY_OP_groupi_n_145 VDD VDD VSS VSS WALLACE_CSA_DUMMY_OP_groupi_n_161 NOR2V1_90S9T20R
XWALLACE_CSA_DUMMY_OP_groupi_g1216__5122 WALLACE_CSA_DUMMY_OP_groupi_n_156 WALLACE_CSA_DUMMY_OP_groupi_n_147 VDD VDD VSS VSS WALLACE_CSA_DUMMY_OP_groupi_n_159 NOR2V1_90S9T20R
XWALLACE_CSA_DUMMY_OP_groupi_g1218__7098 WALLACE_CSA_DUMMY_OP_groupi_n_155 WALLACE_CSA_DUMMY_OP_groupi_n_151 VDD VDD VSS VSS out_4 NAND2V1_90S9T20R
XWALLACE_CSA_DUMMY_OP_groupi_g1219__6131 WALLACE_CSA_DUMMY_OP_groupi_n_153 WALLACE_CSA_DUMMY_OP_groupi_n_136 VDD VDD VSS VSS WALLACE_CSA_DUMMY_OP_groupi_n_156 NOR2V1_90S9T20R
XWALLACE_CSA_DUMMY_OP_groupi_g1220__1881 WALLACE_CSA_DUMMY_OP_groupi_n_146 WALLACE_CSA_DUMMY_OP_groupi_n_144 VDD VDD VSS VSS WALLACE_CSA_DUMMY_OP_groupi_n_155 NAND2V1_90S9T20R
XWALLACE_CSA_DUMMY_OP_groupi_g1221__5115 WALLACE_CSA_DUMMY_OP_groupi_n_147 WALLACE_CSA_DUMMY_OP_groupi_n_145 VDD VDD VSS VSS WALLACE_CSA_DUMMY_OP_groupi_n_154 NOR2V1_90S9T20R
XWALLACE_CSA_DUMMY_OP_groupi_g1222__7482 WALLACE_CSA_DUMMY_OP_groupi_n_146 WALLACE_CSA_DUMMY_OP_groupi_n_137 VDD VDD VSS VSS WALLACE_CSA_DUMMY_OP_groupi_n_153 NOR2V1_90S9T20R
XWALLACE_CSA_DUMMY_OP_groupi_g1223__4733 WALLACE_CSA_DUMMY_OP_groupi_n_150 WALLACE_CSA_DUMMY_OP_groupi_n_149 VDD VDD VSS VSS out_3 NAND2V1_90S9T20R
XWALLACE_CSA_DUMMY_OP_groupi_g1224__6161 WALLACE_CSA_DUMMY_OP_groupi_n_146 WALLACE_CSA_DUMMY_OP_groupi_n_144 VDD VDD VSS VSS WALLACE_CSA_DUMMY_OP_groupi_n_151 OR2V1_90S9T20R
XWALLACE_CSA_DUMMY_OP_groupi_g1225__9315 WALLACE_CSA_DUMMY_OP_groupi_n_142 WALLACE_CSA_DUMMY_OP_groupi_n_126 VDD VDD VSS VSS WALLACE_CSA_DUMMY_OP_groupi_n_150 NAND2V1_90S9T20R
XWALLACE_CSA_DUMMY_OP_groupi_g1226__9945 WALLACE_CSA_DUMMY_OP_groupi_n_142 WALLACE_CSA_DUMMY_OP_groupi_n_126 VDD VDD VSS VSS WALLACE_CSA_DUMMY_OP_groupi_n_149 OR2V1_90S9T20R
XWALLACE_CSA_DUMMY_OP_groupi_g1227__2883 WALLACE_CSA_DUMMY_OP_groupi_n_140 WALLACE_CSA_DUMMY_OP_groupi_n_138 VDD VDD VSS VSS WALLACE_CSA_DUMMY_OP_groupi_n_148 NOR2V1_90S9T20R
XWALLACE_CSA_DUMMY_OP_groupi_g1228__2346 n_191 WALLACE_CSA_DUMMY_OP_groupi_n_129 VDD VDD VSS VSS WALLACE_CSA_DUMMY_OP_groupi_n_147 NOR2V1_90S9T20R
XWALLACE_CSA_DUMMY_OP_groupi_g1229__1666 WALLACE_CSA_DUMMY_OP_groupi_n_143 WALLACE_CSA_DUMMY_OP_groupi_n_131 VDD VDD VSS VSS WALLACE_CSA_DUMMY_OP_groupi_n_146 NOR2V1_90S9T20R
XWALLACE_CSA_DUMMY_OP_groupi_g1230__7410 n_191 WALLACE_CSA_DUMMY_OP_groupi_n_129 VDD VDD VSS VSS WALLACE_CSA_DUMMY_OP_groupi_n_145 AND2V1_90S9T20R
XWALLACE_CSA_DUMMY_OP_groupi_g1231__6417 WALLACE_CSA_DUMMY_OP_groupi_n_137 WALLACE_CSA_DUMMY_OP_groupi_n_136 VDD VDD VSS VSS WALLACE_CSA_DUMMY_OP_groupi_n_144 NOR2V1_90S9T20R
XWALLACE_CSA_DUMMY_OP_groupi_g1232__5477 WALLACE_CSA_DUMMY_OP_groupi_n_135 WALLACE_CSA_DUMMY_OP_groupi_n_126 VDD VDD VSS VSS WALLACE_CSA_DUMMY_OP_groupi_n_143 NOR2V1_90S9T20R
XWALLACE_CSA_DUMMY_OP_groupi_g1233__2398 WALLACE_CSA_DUMMY_OP_groupi_n_135 WALLACE_CSA_DUMMY_OP_groupi_n_131 VDD VDD VSS VSS WALLACE_CSA_DUMMY_OP_groupi_n_142 NOR2V1_90S9T20R
XWALLACE_CSA_DUMMY_OP_groupi_g1234__5107 WALLACE_CSA_DUMMY_OP_groupi_n_133 WALLACE_CSA_DUMMY_OP_groupi_n_0 VDD VDD VSS VSS out_2 NAND2V1_90S9T20R
XWALLACE_CSA_DUMMY_OP_groupi_g1235__6260 WALLACE_CSA_DUMMY_OP_groupi_n_128 n_195 VDD VDD VSS VSS WALLACE_CSA_DUMMY_OP_groupi_n_140 NOR2V1_90S9T20R
XWALLACE_CSA_DUMMY_OP_groupi_g1237__8428 WALLACE_CSA_DUMMY_OP_groupi_n_128 n_195 VDD VDD VSS VSS WALLACE_CSA_DUMMY_OP_groupi_n_138 AND2V1_90S9T20R
XWALLACE_CSA_DUMMY_OP_groupi_g1238__5526 n_192 WALLACE_CSA_DUMMY_OP_groupi_n_117 VDD VDD VSS VSS WALLACE_CSA_DUMMY_OP_groupi_n_137 NOR2V1_90S9T20R
XWALLACE_CSA_DUMMY_OP_groupi_g1239__6783 n_192 WALLACE_CSA_DUMMY_OP_groupi_n_117 VDD VDD VSS VSS WALLACE_CSA_DUMMY_OP_groupi_n_136 AND2V1_90S9T20R
XWALLACE_CSA_DUMMY_OP_groupi_g1242__1617 WALLACE_CSA_DUMMY_OP_groupi_n_124 WALLACE_CSA_DUMMY_OP_groupi_n_104 VDD VDD VSS VSS WALLACE_CSA_DUMMY_OP_groupi_n_133 NAND2V1_90S9T20R
XWALLACE_CSA_DUMMY_OP_groupi_g1244__1705 WALLACE_CSA_DUMMY_OP_groupi_n_122 WALLACE_CSA_DUMMY_OP_groupi_n_95 VDD VDD VSS VSS WALLACE_CSA_DUMMY_OP_groupi_n_135 NOR2V1_90S9T20R
XWALLACE_CSA_DUMMY_OP_groupi_g1245__5122 WALLACE_CSA_DUMMY_OP_groupi_n_122 WALLACE_CSA_DUMMY_OP_groupi_n_95 VDD VDD VSS VSS WALLACE_CSA_DUMMY_OP_groupi_n_131 AND2V1_90S9T20R
XWALLACE_CSA_DUMMY_OP_groupi_g1246__8246 WALLACE_CSA_DUMMY_OP_groupi_n_100 c_7 VDD VDD VSS VSS WALLACE_CSA_DUMMY_OP_groupi_n_130 XNOR2V1_90S9T20R
XWALLACE_CSA_DUMMY_OP_groupi_g1247__7098 n_197 WALLACE_CSA_DUMMY_OP_groupi_n_101 VDD VDD VSS VSS WALLACE_CSA_DUMMY_OP_groupi_n_129 NAND2V1_90S9T20R
XWALLACE_CSA_DUMMY_OP_groupi_g1248__6131 WALLACE_CSA_DUMMY_OP_groupi_n_119 WALLACE_CSA_DUMMY_OP_groupi_n_115 VDD VDD VSS VSS WALLACE_CSA_DUMMY_OP_groupi_n_128 NAND2V1_90S9T20R
XWALLACE_CSA_DUMMY_OP_groupi_g1250__5115 WALLACE_CSA_DUMMY_OP_groupi_n_125 WALLACE_CSA_DUMMY_OP_groupi_n_107 VDD VDD VSS VSS WALLACE_CSA_DUMMY_OP_groupi_n_126 NOR2V1_90S9T20R
XWALLACE_CSA_DUMMY_OP_groupi_g1251__7482 WALLACE_CSA_DUMMY_OP_groupi_n_105 WALLACE_CSA_DUMMY_OP_groupi_n_104 VDD VDD VSS VSS WALLACE_CSA_DUMMY_OP_groupi_n_125 NOR2V1_90S9T20R
XWALLACE_CSA_DUMMY_OP_groupi_g1253__4733 WALLACE_CSA_DUMMY_OP_groupi_n_107 WALLACE_CSA_DUMMY_OP_groupi_n_105 VDD VDD VSS VSS WALLACE_CSA_DUMMY_OP_groupi_n_124 NOR2V1_90S9T20R
XWALLACE_CSA_DUMMY_OP_groupi_g1255__9315 WALLACE_CSA_DUMMY_OP_groupi_n_112 WALLACE_CSA_DUMMY_OP_groupi_n_110 VDD VDD VSS VSS WALLACE_CSA_DUMMY_OP_groupi_n_122 NAND2V1_90S9T20R
XWALLACE_CSA_DUMMY_OP_groupi_g1258__2883 WALLACE_CSA_DUMMY_OP_groupi_n_113 WALLACE_CSA_DUMMY_OP_groupi_n_83 VDD VDD VSS VSS WALLACE_CSA_DUMMY_OP_groupi_n_119 NAND2V1_90S9T20R
XWALLACE_CSA_DUMMY_OP_groupi_g1260__1666 WALLACE_CSA_DUMMY_OP_groupi_n_109 WALLACE_CSA_DUMMY_OP_groupi_n_81 VDD VDD VSS VSS WALLACE_CSA_DUMMY_OP_groupi_n_117 NAND2V1_90S9T20R
XWALLACE_CSA_DUMMY_OP_groupi_g1263__7410 WALLACE_CSA_DUMMY_OP_groupi_n_103 WALLACE_CSA_DUMMY_OP_groupi_n_102 VDD VDD VSS VSS out_1 NAND2V1_90S9T20R
XWALLACE_CSA_DUMMY_OP_groupi_g1265__6417 WALLACE_CSA_DUMMY_OP_groupi_n_87 WALLACE_CSA_DUMMY_OP_groupi_n_41 VDD VDD VSS VSS WALLACE_CSA_DUMMY_OP_groupi_n_115 NAND2V1_90S9T20R
XWALLACE_CSA_DUMMY_OP_groupi_g1267__5477 WALLACE_CSA_DUMMY_OP_groupi_n_86 WALLACE_CSA_DUMMY_OP_groupi_n_41 VDD VDD VSS VSS WALLACE_CSA_DUMMY_OP_groupi_n_114 NAND2V1_90S9T20R
XWALLACE_CSA_DUMMY_OP_groupi_g1268__2398 WALLACE_CSA_DUMMY_OP_groupi_n_86 WALLACE_CSA_DUMMY_OP_groupi_n_42 VDD VDD VSS VSS WALLACE_CSA_DUMMY_OP_groupi_n_113 NAND2V1_90S9T20R
XWALLACE_CSA_DUMMY_OP_groupi_g1269__5107 WALLACE_CSA_DUMMY_OP_groupi_n_99 WALLACE_CSA_DUMMY_OP_groupi_n_89 VDD VDD VSS VSS WALLACE_CSA_DUMMY_OP_groupi_n_112 NAND2V1_90S9T20R
XWALLACE_CSA_DUMMY_OP_groupi_g1270__6260 WALLACE_CSA_DUMMY_OP_groupi_n_87 WALLACE_CSA_DUMMY_OP_groupi_n_42 VDD VDD VSS VSS WALLACE_CSA_DUMMY_OP_groupi_n_111 NAND2V1_90S9T20R
XWALLACE_CSA_DUMMY_OP_groupi_g1271__4319 WALLACE_CSA_DUMMY_OP_groupi_n_98 WALLACE_CSA_DUMMY_OP_groupi_n_88 VDD VDD VSS VSS WALLACE_CSA_DUMMY_OP_groupi_n_110 NAND2V1_90S9T20R
XWALLACE_CSA_DUMMY_OP_groupi_g1272__8428 WALLACE_CSA_DUMMY_OP_groupi_n_89 WALLACE_CSA_DUMMY_OP_groupi_n_78 VDD VDD VSS VSS WALLACE_CSA_DUMMY_OP_groupi_n_109 NAND2V1_90S9T20R
XWALLACE_CSA_DUMMY_OP_groupi_g1274__5526 WALLACE_CSA_DUMMY_OP_groupi_n_90 WALLACE_CSA_DUMMY_OP_groupi_n_35 VDD VDD VSS VSS WALLACE_CSA_DUMMY_OP_groupi_n_103 NAND2V1_90S9T20R
XWALLACE_CSA_DUMMY_OP_groupi_g1275__6783 WALLACE_CSA_DUMMY_OP_groupi_n_91 WALLACE_CSA_DUMMY_OP_groupi_n_36 VDD VDD VSS VSS WALLACE_CSA_DUMMY_OP_groupi_n_102 NAND2V1_90S9T20R
XWALLACE_CSA_DUMMY_OP_groupi_g1276__3680 WALLACE_CSA_DUMMY_OP_groupi_n_85 WALLACE_CSA_DUMMY_OP_groupi_n_53 VDD VDD VSS VSS WALLACE_CSA_DUMMY_OP_groupi_n_101 NAND2V1_90S9T20R
XWALLACE_CSA_DUMMY_OP_groupi_g1278__2802 WALLACE_CSA_DUMMY_OP_groupi_n_97 WALLACE_CSA_DUMMY_OP_groupi_n_47 VDD VDD VSS VSS WALLACE_CSA_DUMMY_OP_groupi_n_107 NOR2V1_90S9T20R
XWALLACE_CSA_DUMMY_OP_groupi_g1279__1705 WALLACE_CSA_DUMMY_OP_groupi_n_94 WALLACE_CSA_DUMMY_OP_groupi_n_30 VDD VDD VSS VSS WALLACE_CSA_DUMMY_OP_groupi_n_100 NOR2V1_90S9T20R
XWALLACE_CSA_DUMMY_OP_groupi_g1281__8246 WALLACE_CSA_DUMMY_OP_groupi_n_96 WALLACE_CSA_DUMMY_OP_groupi_n_48 VDD VDD VSS VSS WALLACE_CSA_DUMMY_OP_groupi_n_105 NOR2V1_90S9T20R
XWALLACE_CSA_DUMMY_OP_groupi_g1282__7098 WALLACE_CSA_DUMMY_OP_groupi_n_84 WALLACE_CSA_DUMMY_OP_groupi_n_73 VDD VDD VSS VSS WALLACE_CSA_DUMMY_OP_groupi_n_104 NOR2V1_90S9T20R
XWALLACE_CSA_DUMMY_OP_groupi_g1283 WALLACE_CSA_DUMMY_OP_groupi_n_98 VDD VDD VSS VSS WALLACE_CSA_DUMMY_OP_groupi_n_99 INV1_90S9T20R
XWALLACE_CSA_DUMMY_OP_groupi_g1284 WALLACE_CSA_DUMMY_OP_groupi_n_96 VDD VDD VSS VSS WALLACE_CSA_DUMMY_OP_groupi_n_97 INV1_90S9T20R
XWALLACE_CSA_DUMMY_OP_groupi_g1285__6131 WALLACE_CSA_DUMMY_OP_groupi_n_69 WALLACE_CSA_DUMMY_OP_groupi_n_32 VDD VDD VSS VSS WALLACE_CSA_DUMMY_OP_groupi_n_94 NOR2V1_90S9T20R
XWALLACE_CSA_DUMMY_OP_groupi_g1288__7482 WALLACE_CSA_DUMMY_OP_groupi_n_80 WALLACE_CSA_DUMMY_OP_groupi_n_76 VDD VDD VSS VSS WALLACE_CSA_DUMMY_OP_groupi_n_98 NAND2V1_90S9T20R
XWALLACE_CSA_DUMMY_OP_groupi_g1289__4733 WALLACE_CSA_DUMMY_OP_groupi_n_79 WALLACE_CSA_DUMMY_OP_groupi_n_77 VDD VDD VSS VSS WALLACE_CSA_DUMMY_OP_groupi_n_96 NAND2V1_90S9T20R
XWALLACE_CSA_DUMMY_OP_groupi_g1290__6161 WALLACE_CSA_DUMMY_OP_groupi_n_66 WALLACE_CSA_DUMMY_OP_groupi_n_39 VDD VDD VSS VSS WALLACE_CSA_DUMMY_OP_groupi_n_95 NAND2V1_90S9T20R
XWALLACE_CSA_DUMMY_OP_groupi_g1293 WALLACE_CSA_DUMMY_OP_groupi_n_90 VDD VDD VSS VSS WALLACE_CSA_DUMMY_OP_groupi_n_91 INV1_90S9T20R
XWALLACE_CSA_DUMMY_OP_groupi_g1294 WALLACE_CSA_DUMMY_OP_groupi_n_88 VDD VDD VSS VSS WALLACE_CSA_DUMMY_OP_groupi_n_89 INV1_90S9T20R
XWALLACE_CSA_DUMMY_OP_groupi_g1295 WALLACE_CSA_DUMMY_OP_groupi_n_87 VDD VDD VSS VSS WALLACE_CSA_DUMMY_OP_groupi_n_86 INV1_90S9T20R
XWALLACE_CSA_DUMMY_OP_groupi_g1298__9315 WALLACE_CSA_DUMMY_OP_groupi_n_74 WALLACE_CSA_DUMMY_OP_groupi_n_36 VDD VDD VSS VSS WALLACE_CSA_DUMMY_OP_groupi_n_84 AND2V1_90S9T20R
XWALLACE_CSA_DUMMY_OP_groupi_g1299__9945 WALLACE_CSA_DUMMY_OP_groupi_n_75 WALLACE_CSA_DUMMY_OP_groupi_n_73 VDD VDD VSS VSS WALLACE_CSA_DUMMY_OP_groupi_n_90 NOR2V1_90S9T20R
XWALLACE_CSA_DUMMY_OP_groupi_g1300__2883 WALLACE_CSA_DUMMY_OP_groupi_n_57 WALLACE_CSA_DUMMY_OP_groupi_n_12 VDD VDD VSS VSS WALLACE_CSA_DUMMY_OP_groupi_n_88 XOR2V1_90S9T20R
XWALLACE_CSA_DUMMY_OP_groupi_g1301__2346 WALLACE_CSA_DUMMY_OP_groupi_n_49 WALLACE_CSA_DUMMY_OP_groupi_n_19 VDD VDD VSS VSS WALLACE_CSA_DUMMY_OP_groupi_n_87 XOR2V1_90S9T20R
XWALLACE_CSA_DUMMY_OP_groupi_g1302__1666 WALLACE_CSA_DUMMY_OP_groupi_n_68 WALLACE_CSA_DUMMY_OP_groupi_n_67 VDD VDD VSS VSS WALLACE_CSA_DUMMY_OP_groupi_n_85 NAND2V1_90S9T20R
XWALLACE_CSA_DUMMY_OP_groupi_g1304__7410 WALLACE_CSA_DUMMY_OP_groupi_n_59 WALLACE_CSA_DUMMY_OP_groupi_n_43 VDD VDD VSS VSS WALLACE_CSA_DUMMY_OP_groupi_n_81 NAND2V1_90S9T20R
XWALLACE_CSA_DUMMY_OP_groupi_g1305__6417 WALLACE_CSA_DUMMY_OP_groupi_n_60 WALLACE_CSA_DUMMY_OP_groupi_n_43 VDD VDD VSS VSS WALLACE_CSA_DUMMY_OP_groupi_n_80 NAND2V1_90S9T20R
XWALLACE_CSA_DUMMY_OP_groupi_g1306__5477 WALLACE_CSA_DUMMY_OP_groupi_n_54 WALLACE_CSA_DUMMY_OP_groupi_n_63 VDD VDD VSS VSS WALLACE_CSA_DUMMY_OP_groupi_n_79 NAND2V1_90S9T20R
XWALLACE_CSA_DUMMY_OP_groupi_g1307__2398 WALLACE_CSA_DUMMY_OP_groupi_n_60 WALLACE_CSA_DUMMY_OP_groupi_n_44 VDD VDD VSS VSS WALLACE_CSA_DUMMY_OP_groupi_n_78 NAND2V1_90S9T20R
XWALLACE_CSA_DUMMY_OP_groupi_g1308__5107 WALLACE_CSA_DUMMY_OP_groupi_n_55 WALLACE_CSA_DUMMY_OP_groupi_n_64 VDD VDD VSS VSS WALLACE_CSA_DUMMY_OP_groupi_n_77 NAND2V1_90S9T20R
XWALLACE_CSA_DUMMY_OP_groupi_g1309__6260 WALLACE_CSA_DUMMY_OP_groupi_n_59 WALLACE_CSA_DUMMY_OP_groupi_n_44 VDD VDD VSS VSS WALLACE_CSA_DUMMY_OP_groupi_n_76 NAND2V1_90S9T20R
XWALLACE_CSA_DUMMY_OP_groupi_g1310__4319 WALLACE_CSA_DUMMY_OP_groupi_n_58 WALLACE_CSA_DUMMY_OP_groupi_n_38 VDD VDD VSS VSS WALLACE_CSA_DUMMY_OP_groupi_n_83 NAND2V1_90S9T20R
XWALLACE_CSA_DUMMY_OP_groupi_g1311 WALLACE_CSA_DUMMY_OP_groupi_n_74 VDD VDD VSS VSS WALLACE_CSA_DUMMY_OP_groupi_n_75 INV1_90S9T20R
XWALLACE_CSA_DUMMY_OP_groupi_g1314__8428 WALLACE_CSA_DUMMY_OP_groupi_n_46 WALLACE_CSA_DUMMY_OP_groupi_n_62 VDD VDD VSS VSS WALLACE_CSA_DUMMY_OP_groupi_n_68 NAND2V1_90S9T20R
XWALLACE_CSA_DUMMY_OP_groupi_g1315__5526 WALLACE_CSA_DUMMY_OP_groupi_n_61 WALLACE_CSA_DUMMY_OP_groupi_n_45 VDD VDD VSS VSS WALLACE_CSA_DUMMY_OP_groupi_n_67 NAND2V1_90S9T20R
XWALLACE_CSA_DUMMY_OP_groupi_g1316__6783 WALLACE_CSA_DUMMY_OP_groupi_n_55 WALLACE_CSA_DUMMY_OP_groupi_n_33 VDD VDD VSS VSS WALLACE_CSA_DUMMY_OP_groupi_n_66 NAND2V1_90S9T20R
XWALLACE_CSA_DUMMY_OP_groupi_g1317__3680 WALLACE_CSA_DUMMY_OP_groupi_n_65 WALLACE_CSA_DUMMY_OP_groupi_n_15 VDD VDD VSS VSS WALLACE_CSA_DUMMY_OP_groupi_n_74 NAND2V1_90S9T20R
XWALLACE_CSA_DUMMY_OP_groupi_g1318__1617 WALLACE_CSA_DUMMY_OP_groupi_n_65 WALLACE_CSA_DUMMY_OP_groupi_n_15 VDD VDD VSS VSS WALLACE_CSA_DUMMY_OP_groupi_n_73 NOR2V1_90S9T20R
XWALLACE_CSA_DUMMY_OP_groupi_g1319__2802 WALLACE_CSA_DUMMY_OP_groupi_n_50 WALLACE_CSA_DUMMY_OP_groupi_n_37 VDD VDD VSS VSS WALLACE_CSA_DUMMY_OP_groupi_n_71 NOR2V1_90S9T20R
XWALLACE_CSA_DUMMY_OP_groupi_g1320__1705 WALLACE_CSA_DUMMY_OP_groupi_n_51 WALLACE_CSA_DUMMY_OP_groupi_n_40 VDD VDD VSS VSS WALLACE_CSA_DUMMY_OP_groupi_n_69 NOR2V1_90S9T20R
XWALLACE_CSA_DUMMY_OP_groupi_g1321 WALLACE_CSA_DUMMY_OP_groupi_n_63 VDD VDD VSS VSS WALLACE_CSA_DUMMY_OP_groupi_n_64 INV1_90S9T20R
XWALLACE_CSA_DUMMY_OP_groupi_g1322 WALLACE_CSA_DUMMY_OP_groupi_n_61 VDD VDD VSS VSS WALLACE_CSA_DUMMY_OP_groupi_n_62 INV1_90S9T20R
XWALLACE_CSA_DUMMY_OP_groupi_g1323 WALLACE_CSA_DUMMY_OP_groupi_n_60 VDD VDD VSS VSS WALLACE_CSA_DUMMY_OP_groupi_n_59 INV1_90S9T20R
XWALLACE_CSA_DUMMY_OP_groupi_g1324__5122 WALLACE_CSA_DUMMY_OP_groupi_n_46 WALLACE_CSA_DUMMY_OP_groupi_n_34 VDD VDD VSS VSS WALLACE_CSA_DUMMY_OP_groupi_n_58 NAND2V1_90S9T20R
XWALLACE_CSA_DUMMY_OP_groupi_g1325__8246 WALLACE_CSA_DUMMY_OP_groupi_n_17 WALLACE_CSA_DUMMY_OP_groupi_n_8 VDD VDD VSS VSS WALLACE_CSA_DUMMY_OP_groupi_n_57 XOR2V1_90S9T20R
XWALLACE_CSA_DUMMY_OP_groupi_g1326__7098 WALLACE_CSA_DUMMY_OP_groupi_n_23 c_1 VDD VDD VSS VSS WALLACE_CSA_DUMMY_OP_groupi_n_65 XOR2V1_90S9T20R
XWALLACE_CSA_DUMMY_OP_groupi_g1327__6131 WALLACE_CSA_DUMMY_OP_groupi_n_9 WALLACE_CSA_DUMMY_OP_groupi_n_20 VDD VDD VSS VSS WALLACE_CSA_DUMMY_OP_groupi_n_63 XOR2V1_90S9T20R
XWALLACE_CSA_DUMMY_OP_groupi_g1328__1881 WALLACE_CSA_DUMMY_OP_groupi_n_7 WALLACE_CSA_DUMMY_OP_groupi_n_18 VDD VDD VSS VSS WALLACE_CSA_DUMMY_OP_groupi_n_61 XOR2V1_90S9T20R
XWALLACE_CSA_DUMMY_OP_groupi_g1329__5115 WALLACE_CSA_DUMMY_OP_groupi_n_13 c_3 VDD VDD VSS VSS WALLACE_CSA_DUMMY_OP_groupi_n_60 XOR2V1_90S9T20R
XWALLACE_CSA_DUMMY_OP_groupi_g1330 WALLACE_CSA_DUMMY_OP_groupi_n_54 VDD VDD VSS VSS WALLACE_CSA_DUMMY_OP_groupi_n_55 INV1_90S9T20R
XWALLACE_CSA_DUMMY_OP_groupi_g1331__7482 WALLACE_CSA_DUMMY_OP_groupi_n_36 WALLACE_CSA_DUMMY_OP_groupi_n_28 VDD VDD VSS VSS out_0 NOR2V1_90S9T20R
XWALLACE_CSA_DUMMY_OP_groupi_g1332__4733 WALLACE_CSA_DUMMY_OP_groupi_n_31 WALLACE_CSA_DUMMY_OP_groupi_n_27 VDD VDD VSS VSS WALLACE_CSA_DUMMY_OP_groupi_n_51 NOR2V1_90S9T20R
XWALLACE_CSA_DUMMY_OP_groupi_g1333__6161 WALLACE_CSA_DUMMY_OP_groupi_n_29 WALLACE_CSA_DUMMY_OP_groupi_n_12 VDD VDD VSS VSS WALLACE_CSA_DUMMY_OP_groupi_n_50 NOR2V1_90S9T20R
XWALLACE_CSA_DUMMY_OP_groupi_g1334__9315 WALLACE_CSA_DUMMY_OP_groupi_n_11 c_6 VDD VDD VSS VSS WALLACE_CSA_DUMMY_OP_groupi_n_56 XOR2V1_90S9T20R
XWALLACE_CSA_DUMMY_OP_groupi_g1335__9945 WALLACE_CSA_DUMMY_OP_groupi_n_27 c_5 VDD VDD VSS VSS WALLACE_CSA_DUMMY_OP_groupi_n_49 XOR2V1_90S9T20R
XWALLACE_CSA_DUMMY_OP_groupi_g1336__2883 WALLACE_CSA_DUMMY_OP_groupi_n_25 c_2 VDD VDD VSS VSS WALLACE_CSA_DUMMY_OP_groupi_n_54 XOR2V1_90S9T20R
XWALLACE_CSA_DUMMY_OP_groupi_g1337__2346 WALLACE_CSA_DUMMY_OP_groupi_n_21 c_4 VDD VDD VSS VSS WALLACE_CSA_DUMMY_OP_groupi_n_53 XNOR2V1_90S9T20R
XWALLACE_CSA_DUMMY_OP_groupi_g1338 WALLACE_CSA_DUMMY_OP_groupi_n_47 VDD VDD VSS VSS WALLACE_CSA_DUMMY_OP_groupi_n_48 INV1_90S9T20R
XWALLACE_CSA_DUMMY_OP_groupi_g1339 WALLACE_CSA_DUMMY_OP_groupi_n_45 VDD VDD VSS VSS WALLACE_CSA_DUMMY_OP_groupi_n_46 INV1_90S9T20R
XWALLACE_CSA_DUMMY_OP_groupi_g1340 WALLACE_CSA_DUMMY_OP_groupi_n_44 VDD VDD VSS VSS WALLACE_CSA_DUMMY_OP_groupi_n_43 INV1_90S9T20R
XWALLACE_CSA_DUMMY_OP_groupi_g1341 WALLACE_CSA_DUMMY_OP_groupi_n_42 VDD VDD VSS VSS WALLACE_CSA_DUMMY_OP_groupi_n_41 INV1_90S9T20R
XWALLACE_CSA_DUMMY_OP_groupi_g1342__1666 WALLACE_CSA_DUMMY_OP_groupi_n_19 WALLACE_CSA_DUMMY_OP_groupi_n_6 VDD VDD VSS VSS WALLACE_CSA_DUMMY_OP_groupi_n_40 NOR2V1_90S9T20R
XWALLACE_CSA_DUMMY_OP_groupi_g1343__7410 WALLACE_CSA_DUMMY_OP_groupi_n_9 WALLACE_CSA_DUMMY_OP_groupi_n_20 VDD VDD VSS VSS WALLACE_CSA_DUMMY_OP_groupi_n_39 OR2V1_90S9T20R
XWALLACE_CSA_DUMMY_OP_groupi_g1344__6417 WALLACE_CSA_DUMMY_OP_groupi_n_7 WALLACE_CSA_DUMMY_OP_groupi_n_18 VDD VDD VSS VSS WALLACE_CSA_DUMMY_OP_groupi_n_38 OR2V1_90S9T20R
XWALLACE_CSA_DUMMY_OP_groupi_g1345__5477 WALLACE_CSA_DUMMY_OP_groupi_n_17 WALLACE_CSA_DUMMY_OP_groupi_n_8 VDD VDD VSS VSS WALLACE_CSA_DUMMY_OP_groupi_n_37 NOR2V1_90S9T20R
XWALLACE_CSA_DUMMY_OP_groupi_g1346__2398 WALLACE_CSA_DUMMY_OP_groupi_n_24 c_1 VDD VDD VSS VSS WALLACE_CSA_DUMMY_OP_groupi_n_47 NAND2V1_90S9T20R
XWALLACE_CSA_DUMMY_OP_groupi_g1347__5107 WALLACE_CSA_DUMMY_OP_groupi_n_14 c_3 VDD VDD VSS VSS WALLACE_CSA_DUMMY_OP_groupi_n_45 NAND2V1_90S9T20R
XWALLACE_CSA_DUMMY_OP_groupi_g1348__6260 WALLACE_CSA_DUMMY_OP_groupi_n_26 c_2 VDD VDD VSS VSS WALLACE_CSA_DUMMY_OP_groupi_n_44 NAND2V1_90S9T20R
XWALLACE_CSA_DUMMY_OP_groupi_g1349__4319 WALLACE_CSA_DUMMY_OP_groupi_n_22 c_4 VDD VDD VSS VSS WALLACE_CSA_DUMMY_OP_groupi_n_42 NAND2V1_90S9T20R
XWALLACE_CSA_DUMMY_OP_groupi_g1350 WALLACE_CSA_DUMMY_OP_groupi_n_35 VDD VDD VSS VSS WALLACE_CSA_DUMMY_OP_groupi_n_36 INV1_90S9T20R
XWALLACE_CSA_DUMMY_OP_groupi_g1351__8428 WALLACE_CSA_DUMMY_OP_groupi_n_18 WALLACE_CSA_DUMMY_OP_groupi_n_7 VDD VDD VSS VSS WALLACE_CSA_DUMMY_OP_groupi_n_34 NAND2V1_90S9T20R
XWALLACE_CSA_DUMMY_OP_groupi_g1352__5526 WALLACE_CSA_DUMMY_OP_groupi_n_20 WALLACE_CSA_DUMMY_OP_groupi_n_9 VDD VDD VSS VSS WALLACE_CSA_DUMMY_OP_groupi_n_33 NAND2V1_90S9T20R
XWALLACE_CSA_DUMMY_OP_groupi_g1353__6783 WALLACE_CSA_DUMMY_OP_groupi_n_10 c_6 VDD VDD VSS VSS WALLACE_CSA_DUMMY_OP_groupi_n_32 NOR2V1_90S9T20R
XWALLACE_CSA_DUMMY_OP_groupi_g1354__3680 WALLACE_CSA_DUMMY_OP_groupi_n_19 WALLACE_CSA_DUMMY_OP_groupi_n_6 VDD VDD VSS VSS WALLACE_CSA_DUMMY_OP_groupi_n_31 AND2V1_90S9T20R
XWALLACE_CSA_DUMMY_OP_groupi_g1355__1617 WALLACE_CSA_DUMMY_OP_groupi_n_11 WALLACE_CSA_DUMMY_OP_groupi_n_5 VDD VDD VSS VSS WALLACE_CSA_DUMMY_OP_groupi_n_30 NOR2V1_90S9T20R
XWALLACE_CSA_DUMMY_OP_groupi_g1356__2802 WALLACE_CSA_DUMMY_OP_groupi_n_8 WALLACE_CSA_DUMMY_OP_groupi_n_17 VDD VDD VSS VSS WALLACE_CSA_DUMMY_OP_groupi_n_29 AND2V1_90S9T20R
XWALLACE_CSA_DUMMY_OP_groupi_g1357__1705 WALLACE_CSA_DUMMY_OP_groupi_n_16 c_0 VDD VDD VSS VSS WALLACE_CSA_DUMMY_OP_groupi_n_28 NOR2V1_90S9T20R
XWALLACE_CSA_DUMMY_OP_groupi_g1358__5122 WALLACE_CSA_DUMMY_OP_groupi_n_16 c_0 VDD VDD VSS VSS WALLACE_CSA_DUMMY_OP_groupi_n_35 NAND2V1_90S9T20R
XWALLACE_CSA_DUMMY_OP_groupi_g1359 WALLACE_CSA_DUMMY_OP_groupi_n_25 VDD VDD VSS VSS WALLACE_CSA_DUMMY_OP_groupi_n_26 INV1_90S9T20R
XWALLACE_CSA_DUMMY_OP_groupi_g1360 WALLACE_CSA_DUMMY_OP_groupi_n_23 VDD VDD VSS VSS WALLACE_CSA_DUMMY_OP_groupi_n_24 INV1_90S9T20R
XWALLACE_CSA_DUMMY_OP_groupi_g1361 WALLACE_CSA_DUMMY_OP_groupi_n_21 VDD VDD VSS VSS WALLACE_CSA_DUMMY_OP_groupi_n_22 INV1_90S9T20R
XWALLACE_CSA_DUMMY_OP_groupi_g1362__8246 a_3 b_2 VDD VDD VSS VSS WALLACE_CSA_DUMMY_OP_groupi_n_27 NAND2V1_90S9T20R
XWALLACE_CSA_DUMMY_OP_groupi_g1363__7098 a_2 b_0 VDD VDD VSS VSS WALLACE_CSA_DUMMY_OP_groupi_n_25 NAND2V1_90S9T20R
XWALLACE_CSA_DUMMY_OP_groupi_g1364__6131 a_0 b_1 VDD VDD VSS VSS WALLACE_CSA_DUMMY_OP_groupi_n_23 NAND2V1_90S9T20R
XWALLACE_CSA_DUMMY_OP_groupi_g1365__1881 a_3 b_1 VDD VDD VSS VSS WALLACE_CSA_DUMMY_OP_groupi_n_21 NAND2V1_90S9T20R
XWALLACE_CSA_DUMMY_OP_groupi_g1366__5115 a_1 b_1 VDD VDD VSS VSS WALLACE_CSA_DUMMY_OP_groupi_n_20 NAND2V1_90S9T20R
XWALLACE_CSA_DUMMY_OP_groupi_g1367__7482 a_2 b_3 VDD VDD VSS VSS WALLACE_CSA_DUMMY_OP_groupi_n_19 NAND2V1_90S9T20R
XWALLACE_CSA_DUMMY_OP_groupi_g1368__4733 a_2 b_2 VDD VDD VSS VSS WALLACE_CSA_DUMMY_OP_groupi_n_18 NAND2V1_90S9T20R
XWALLACE_CSA_DUMMY_OP_groupi_g1369__6161 a_0 b_3 VDD VDD VSS VSS WALLACE_CSA_DUMMY_OP_groupi_n_17 NAND2V1_90S9T20R
XWALLACE_CSA_DUMMY_OP_groupi_g1370 WALLACE_CSA_DUMMY_OP_groupi_n_13 VDD VDD VSS VSS WALLACE_CSA_DUMMY_OP_groupi_n_14 INV1_90S9T20R
XWALLACE_CSA_DUMMY_OP_groupi_g1371 WALLACE_CSA_DUMMY_OP_groupi_n_11 VDD VDD VSS VSS WALLACE_CSA_DUMMY_OP_groupi_n_10 INV1_90S9T20R
XWALLACE_CSA_DUMMY_OP_groupi_g1372__9315 a_0 b_0 VDD VDD VSS VSS WALLACE_CSA_DUMMY_OP_groupi_n_16 AND2V1_90S9T20R
XWALLACE_CSA_DUMMY_OP_groupi_g1373__9945 a_1 b_0 VDD VDD VSS VSS WALLACE_CSA_DUMMY_OP_groupi_n_15 NAND2V1_90S9T20R
XWALLACE_CSA_DUMMY_OP_groupi_g1374__2883 a_3 b_0 VDD VDD VSS VSS WALLACE_CSA_DUMMY_OP_groupi_n_13 NAND2V1_90S9T20R
XWALLACE_CSA_DUMMY_OP_groupi_g1375__2346 a_2 b_1 VDD VDD VSS VSS WALLACE_CSA_DUMMY_OP_groupi_n_12 NAND2V1_90S9T20R
XWALLACE_CSA_DUMMY_OP_groupi_g1376__1666 a_3 b_3 VDD VDD VSS VSS WALLACE_CSA_DUMMY_OP_groupi_n_11 NAND2V1_90S9T20R
XWALLACE_CSA_DUMMY_OP_groupi_g1377__7410 a_0 b_2 VDD VDD VSS VSS WALLACE_CSA_DUMMY_OP_groupi_n_9 NAND2V1_90S9T20R
XWALLACE_CSA_DUMMY_OP_groupi_g1378__6417 a_1 b_2 VDD VDD VSS VSS WALLACE_CSA_DUMMY_OP_groupi_n_8 NAND2V1_90S9T20R
XWALLACE_CSA_DUMMY_OP_groupi_g1379__5477 a_1 b_3 VDD VDD VSS VSS WALLACE_CSA_DUMMY_OP_groupi_n_7 NAND2V1_90S9T20R
XWALLACE_CSA_DUMMY_OP_groupi_g1380 c_5 VDD VDD VSS VSS WALLACE_CSA_DUMMY_OP_groupi_n_6 INV1_90S9T20R
XWALLACE_CSA_DUMMY_OP_groupi_g1381 c_6 VDD VDD VSS VSS WALLACE_CSA_DUMMY_OP_groupi_n_5 INV1_90S9T20R
XWALLACE_CSA_DUMMY_OP_groupi_g1385__8428 WALLACE_CSA_DUMMY_OP_groupi_n_124 WALLACE_CSA_DUMMY_OP_groupi_n_104 VDD VDD VSS VSS WALLACE_CSA_DUMMY_OP_groupi_n_0 OR2V1_90S9T20R
Xg2 WALLACE_CSA_DUMMY_OP_groupi_n_166 WALLACE_CSA_DUMMY_OP_groupi_n_130 VDD VDD VSS VSS out_7 XNOR2V1_90S9T20R
Xg1386 WALLACE_CSA_DUMMY_OP_groupi_n_161 WALLACE_CSA_DUMMY_OP_groupi_n_148 VDD VDD VSS VSS out_6 XNOR2V1_90S9T20R
Xg1387 WALLACE_CSA_DUMMY_OP_groupi_n_156 WALLACE_CSA_DUMMY_OP_groupi_n_154 VDD VDD VSS VSS out_5 XNOR2V1_90S9T20R
Xg1388 n_190 WALLACE_CSA_DUMMY_OP_groupi_n_83 VDD VDD VSS VSS n_191 XOR2V1_90S9T20R
Xg3 WALLACE_CSA_DUMMY_OP_groupi_n_114 WALLACE_CSA_DUMMY_OP_groupi_n_111 VDD VDD VSS VSS n_190 NAND2V1_90S9T20R
Xg1389 n_194 WALLACE_CSA_DUMMY_OP_groupi_n_85 VDD VDD VSS VSS n_192 XNOR2V1_90S9T20R
Xg1391 WALLACE_CSA_DUMMY_OP_groupi_n_71 WALLACE_CSA_DUMMY_OP_groupi_n_53 VDD VDD VSS VSS n_194 XOR2V1_90S9T20R
Xg1392 WALLACE_CSA_DUMMY_OP_groupi_n_69 WALLACE_CSA_DUMMY_OP_groupi_n_56 VDD VDD VSS VSS n_195 XOR2V1_90S9T20R
Xg1393 n_196 WALLACE_CSA_DUMMY_OP_groupi_n_71 VDD VDD VSS VSS n_197 OR2V1_90S9T20R
Xg1394 WALLACE_CSA_DUMMY_OP_groupi_n_85 WALLACE_CSA_DUMMY_OP_groupi_n_53 VDD VDD VSS VSS n_196 NOR2V1_90S9T20R
.ENDS MAC4bit
