// Auto-generated integrated Verilog-A: IV + CV, for HSPICE.
// P-type: Id + Cgg in one module.

module nnmodel_p_type (g, d, s, b, cgs_out, cgd_out, cgg_out, gnd);
  inout g, d, s, b, cgs_out, cgd_out, cgg_out, gnd;
  electrical g, d, s, b, cgs_out, cgd_out, cgg_out, gnd;
  parameter real l = 0.018;  // um (match training scaler); do NOT use meters
  parameter real nfin = 1;
  parameter real eot = 1e-09;  // m
  parameter real Isj = 3e-5;   // junction saturation current (3x previous; fit from BSIM card)
  parameter real Nj = 1.28;        // junction emission coefficient
  parameter real enable_junction = 1;  // 0 = off for DC diag (channel-only Id); 1 = normal
  parameter real VTH_EFF  = 0.30;     // effective threshold (V): PMOS use positive, check Vsg
  parameter real VTSCALE  = 0.02585;  // kT/q @ 300K (V)
  parameter real OFF_GAIN = 5.0;      // off-region slope (>=5 ~BSIM-like)
  real x0,x1,x2,x3,x4,x5,x6;
  real gate_exp;
  real xs_dc_0,xs_dc_1,xs_dc_2,xs_dc_3,xs_dc_4,xs_dc_5,xs_dc_6;
  real h1_dc_0, h1_dc_1, h1_dc_2, h1_dc_3, h1_dc_4, h1_dc_5, h1_dc_6, h1_dc_7, h1_dc_8, h1_dc_9, h1_dc_10, h1_dc_11, h1_dc_12, h1_dc_13, h1_dc_14, h1_dc_15;
  real h2_dc_0, h2_dc_1, h2_dc_2, h2_dc_3, h2_dc_4, h2_dc_5, h2_dc_6, h2_dc_7, h2_dc_8, h2_dc_9, h2_dc_10, h2_dc_11, h2_dc_12, h2_dc_13, h2_dc_14, h2_dc_15, h2_dc_16, h2_dc_17, h2_dc_18, h2_dc_19, h2_dc_20, h2_dc_21, h2_dc_22, h2_dc_23, h2_dc_24, h2_dc_25, h2_dc_26, h2_dc_27, h2_dc_28, h2_dc_29, h2_dc_30, h2_dc_31;
  real h3_dc_0, h3_dc_1, h3_dc_2, h3_dc_3, h3_dc_4, h3_dc_5, h3_dc_6, h3_dc_7;
  real y0_dc, id_log, id_raw, Id_si;
  real Vdb, Vsb;  // junction diode: d/s relative to b (PMOS body=nwell, b=VDD)
  real xs_ac_0,xs_ac_1,xs_ac_2,xs_ac_3,xs_ac_4,xs_ac_5,xs_ac_6;
  real h1_ac_0, h1_ac_1, h1_ac_2, h1_ac_3, h1_ac_4, h1_ac_5, h1_ac_6, h1_ac_7, h1_ac_8, h1_ac_9, h1_ac_10, h1_ac_11, h1_ac_12, h1_ac_13, h1_ac_14, h1_ac_15;
  real h2_ac_0, h2_ac_1, h2_ac_2, h2_ac_3, h2_ac_4, h2_ac_5, h2_ac_6, h2_ac_7, h2_ac_8, h2_ac_9, h2_ac_10, h2_ac_11, h2_ac_12, h2_ac_13, h2_ac_14, h2_ac_15, h2_ac_16, h2_ac_17, h2_ac_18, h2_ac_19, h2_ac_20, h2_ac_21, h2_ac_22, h2_ac_23, h2_ac_24, h2_ac_25, h2_ac_26, h2_ac_27, h2_ac_28, h2_ac_29, h2_ac_30, h2_ac_31;
  real h3_ac_0, h3_ac_1, h3_ac_2, h3_ac_3, h3_ac_4, h3_ac_5, h3_ac_6, h3_ac_7;
  real y0_ac, y1_ac, y2_ac, Cgs, Cgd, Cgg;
  real gi;
  analog begin
    x0 = l; x1 = nfin; x2 = eot; x3 = V(g,s); x4 = V(d,s); x5 = V(s,gnd); x6 = V(b,gnd);
    xs_dc_0 = (x0 - 1.8033116849671516e-02) / 2.810036304195497e-03;
    xs_dc_1 = (x1 - 2.505844155844156e+00) / 1.1214981291266748e+00;
    xs_dc_2 = (x2 - 1.4984090833914697e-09) / 3.190093225651217e-10;
    xs_dc_3 = (x3 - -5.000000005321843e-01) / 3.027650336227336e-01;
    xs_dc_4 = (x4 - -5.226298707440592e-01) / 2.853584521666427e-01;
    xs_dc_5 = (x5 - 0.0) / 1.0;
    xs_dc_6 = (x6 - 0.0) / 1.0;
    h1_dc_0 = 3.3783024549484253e-01*xs_dc_0 + -3.0156776309013367e-01*xs_dc_1 + -6.1224158853292465e-02*xs_dc_2 + 4.057636260986328e-01*xs_dc_3 + 3.016122579574585e-01*xs_dc_4 + 0.0*xs_dc_5 + 0.0*xs_dc_6 + -1.9634117186069489e-01;
    gi = 0.5*(h1_dc_0)*(1 + tanh(0.7978845608*((h1_dc_0) + 0.044715*(h1_dc_0)*(h1_dc_0)*(h1_dc_0)))); h1_dc_0 = gi;
    h1_dc_1 = -3.487143665552139e-02*xs_dc_0 + 1.0793892294168472e-01*xs_dc_1 + -7.625838369131088e-02*xs_dc_2 + -6.470609903335571e-01*xs_dc_3 + 9.855956435203552e-01*xs_dc_4 + 0.0*xs_dc_5 + 0.0*xs_dc_6 + -6.135109663009644e-01;
    gi = 0.5*(h1_dc_1)*(1 + tanh(0.7978845608*((h1_dc_1) + 0.044715*(h1_dc_1)*(h1_dc_1)*(h1_dc_1)))); h1_dc_1 = gi;
    h1_dc_2 = 1.483046798966825e-03*xs_dc_0 + 3.361615538597107e-01*xs_dc_1 + -4.0330472588539124e-01*xs_dc_2 + 2.1171769499778748e-01*xs_dc_3 + -6.849421770311892e-04*xs_dc_4 + 0.0*xs_dc_5 + 0.0*xs_dc_6 + 6.17337878793478e-03;
    gi = 0.5*(h1_dc_2)*(1 + tanh(0.7978845608*((h1_dc_2) + 0.044715*(h1_dc_2)*(h1_dc_2)*(h1_dc_2)))); h1_dc_2 = gi;
    h1_dc_3 = -7.588252890855074e-03*xs_dc_0 + -6.116645932197571e-01*xs_dc_1 + -1.4137836173176765e-02*xs_dc_2 + -1.3382753357291222e-02*xs_dc_3 + -1.0595839470624924e-01*xs_dc_4 + 0.0*xs_dc_5 + 0.0*xs_dc_6 + -2.765803337097168e-01;
    gi = 0.5*(h1_dc_3)*(1 + tanh(0.7978845608*((h1_dc_3) + 0.044715*(h1_dc_3)*(h1_dc_3)*(h1_dc_3)))); h1_dc_3 = gi;
    h1_dc_4 = 6.04974739253521e-02*xs_dc_0 + 4.173465967178345e-01*xs_dc_1 + -1.494988352060318e-01*xs_dc_2 + 5.136874914169312e-01*xs_dc_3 + 9.006606042385101e-02*xs_dc_4 + 0.0*xs_dc_5 + 0.0*xs_dc_6 + -1.8140241503715515e-02;
    gi = 0.5*(h1_dc_4)*(1 + tanh(0.7978845608*((h1_dc_4) + 0.044715*(h1_dc_4)*(h1_dc_4)*(h1_dc_4)))); h1_dc_4 = gi;
    h1_dc_5 = -7.24668875336647e-02*xs_dc_0 + 3.549324572086334e-01*xs_dc_1 + -5.884842947125435e-02*xs_dc_2 + -2.5376027822494507e-01*xs_dc_3 + 1.9051921367645264e-01*xs_dc_4 + 0.0*xs_dc_5 + 0.0*xs_dc_6 + 7.820966094732285e-02;
    gi = 0.5*(h1_dc_5)*(1 + tanh(0.7978845608*((h1_dc_5) + 0.044715*(h1_dc_5)*(h1_dc_5)*(h1_dc_5)))); h1_dc_5 = gi;
    h1_dc_6 = 3.653326630592346e-01*xs_dc_0 + -3.160461038351059e-02*xs_dc_1 + -2.3276793956756592e-01*xs_dc_2 + -6.029883027076721e-01*xs_dc_3 + 1.3789339922368526e-02*xs_dc_4 + 0.0*xs_dc_5 + 0.0*xs_dc_6 + 6.297605037689209e-01;
    gi = 0.5*(h1_dc_6)*(1 + tanh(0.7978845608*((h1_dc_6) + 0.044715*(h1_dc_6)*(h1_dc_6)*(h1_dc_6)))); h1_dc_6 = gi;
    h1_dc_7 = -1.7391176521778107e-01*xs_dc_0 + 9.144514799118042e-02*xs_dc_1 + 4.857872799038887e-02*xs_dc_2 + 8.628034591674805e-01*xs_dc_3 + -1.1344334483146667e-01*xs_dc_4 + 0.0*xs_dc_5 + 0.0*xs_dc_6 + 9.051923640072346e-03;
    gi = 0.5*(h1_dc_7)*(1 + tanh(0.7978845608*((h1_dc_7) + 0.044715*(h1_dc_7)*(h1_dc_7)*(h1_dc_7)))); h1_dc_7 = gi;
    h1_dc_8 = -8.719061315059662e-02*xs_dc_0 + -3.4358520060777664e-02*xs_dc_1 + -3.410274088382721e-01*xs_dc_2 + 5.262191295623779e-01*xs_dc_3 + -4.450315237045288e-02*xs_dc_4 + 0.0*xs_dc_5 + 0.0*xs_dc_6 + -1.7172940075397491e-01;
    gi = 0.5*(h1_dc_8)*(1 + tanh(0.7978845608*((h1_dc_8) + 0.044715*(h1_dc_8)*(h1_dc_8)*(h1_dc_8)))); h1_dc_8 = gi;
    h1_dc_9 = 1.9543401896953583e-01*xs_dc_0 + -4.154931604862213e-01*xs_dc_1 + 1.3503415882587433e-01*xs_dc_2 + 8.266422152519226e-01*xs_dc_3 + 4.271678328514099e-01*xs_dc_4 + 0.0*xs_dc_5 + 0.0*xs_dc_6 + -5.539906024932861e-02;
    gi = 0.5*(h1_dc_9)*(1 + tanh(0.7978845608*((h1_dc_9) + 0.044715*(h1_dc_9)*(h1_dc_9)*(h1_dc_9)))); h1_dc_9 = gi;
    h1_dc_10 = -2.54361629486084e-01*xs_dc_0 + 4.3477576971054077e-01*xs_dc_1 + -9.303205460309982e-02*xs_dc_2 + -6.308133006095886e-01*xs_dc_3 + -4.2087602615356445e-01*xs_dc_4 + 0.0*xs_dc_5 + 0.0*xs_dc_6 + 3.1207355856895447e-01;
    gi = 0.5*(h1_dc_10)*(1 + tanh(0.7978845608*((h1_dc_10) + 0.044715*(h1_dc_10)*(h1_dc_10)*(h1_dc_10)))); h1_dc_10 = gi;
    h1_dc_11 = -3.72311532497406e-01*xs_dc_0 + -2.4793210625648499e-01*xs_dc_1 + 3.6326509714126587e-01*xs_dc_2 + -2.773926258087158e-01*xs_dc_3 + 2.0657384395599365e-01*xs_dc_4 + 0.0*xs_dc_5 + 0.0*xs_dc_6 + 1.3482403755187988e-01;
    gi = 0.5*(h1_dc_11)*(1 + tanh(0.7978845608*((h1_dc_11) + 0.044715*(h1_dc_11)*(h1_dc_11)*(h1_dc_11)))); h1_dc_11 = gi;
    h1_dc_12 = -8.272349089384079e-02*xs_dc_0 + 1.681824028491974e-01*xs_dc_1 + 1.977349817752838e-02*xs_dc_2 + -6.891151517629623e-02*xs_dc_3 + 1.1518962383270264e+00*xs_dc_4 + 0.0*xs_dc_5 + 0.0*xs_dc_6 + -1.165209174156189e+00;
    gi = 0.5*(h1_dc_12)*(1 + tanh(0.7978845608*((h1_dc_12) + 0.044715*(h1_dc_12)*(h1_dc_12)*(h1_dc_12)))); h1_dc_12 = gi;
    h1_dc_13 = 3.388999104499817e-01*xs_dc_0 + 6.730127334594727e-02*xs_dc_1 + -2.599720060825348e-01*xs_dc_2 + 5.338740348815918e-01*xs_dc_3 + -1.1322055757045746e-01*xs_dc_4 + 0.0*xs_dc_5 + 0.0*xs_dc_6 + -6.309682130813599e-02;
    gi = 0.5*(h1_dc_13)*(1 + tanh(0.7978845608*((h1_dc_13) + 0.044715*(h1_dc_13)*(h1_dc_13)*(h1_dc_13)))); h1_dc_13 = gi;
    h1_dc_14 = 8.960660547018051e-02*xs_dc_0 + 2.43384912610054e-02*xs_dc_1 + -1.435365229845047e-01*xs_dc_2 + 9.894614815711975e-01*xs_dc_3 + -9.403836727142334e-02*xs_dc_4 + 0.0*xs_dc_5 + 0.0*xs_dc_6 + -3.627168480306864e-03;
    gi = 0.5*(h1_dc_14)*(1 + tanh(0.7978845608*((h1_dc_14) + 0.044715*(h1_dc_14)*(h1_dc_14)*(h1_dc_14)))); h1_dc_14 = gi;
    h1_dc_15 = 2.3974092304706573e-01*xs_dc_0 + 2.565685510635376e-01*xs_dc_1 + -3.4677499532699585e-01*xs_dc_2 + 3.637828826904297e-01*xs_dc_3 + -3.063860237598419e-01*xs_dc_4 + 0.0*xs_dc_5 + 0.0*xs_dc_6 + -6.374051421880722e-02;
    gi = 0.5*(h1_dc_15)*(1 + tanh(0.7978845608*((h1_dc_15) + 0.044715*(h1_dc_15)*(h1_dc_15)*(h1_dc_15)))); h1_dc_15 = gi;
    h2_dc_0 = -4.477083384990692e-01*h1_dc_0 + 6.076164171099663e-02*h1_dc_1 + 5.1064059138298035e-02*h1_dc_2 + 1.03607177734375e-02*h1_dc_3 + -2.164924144744873e-01*h1_dc_4 + 6.66753351688385e-02*h1_dc_5 + 3.211962580680847e-01*h1_dc_6 + 2.2205688059329987e-01*h1_dc_7 + -3.992030620574951e-01*h1_dc_8 + -4.8562273383140564e-02*h1_dc_9 + 5.118650943040848e-02*h1_dc_10 + 2.808605693280697e-02*h1_dc_11 + 8.655805140733719e-02*h1_dc_12 + -5.519964098930359e-01*h1_dc_13 + -9.903433918952942e-02*h1_dc_14 + -7.086262106895447e-02*h1_dc_15 + 2.979290187358856e-01;
    gi = 0.5*(h2_dc_0)*(1 + tanh(0.7978845608*((h2_dc_0) + 0.044715*(h2_dc_0)*(h2_dc_0)*(h2_dc_0)))); h2_dc_0 = gi;
    h2_dc_1 = 2.5385138392448425e-01*h1_dc_0 + 2.837800681591034e-01*h1_dc_1 + 2.7491068840026855e-01*h1_dc_2 + 2.843704540282488e-03*h1_dc_3 + -7.037097215652466e-02*h1_dc_4 + 5.320782959461212e-02*h1_dc_5 + 2.3506850004196167e-01*h1_dc_6 + -3.8167569041252136e-01*h1_dc_7 + 2.5434964895248413e-01*h1_dc_8 + -4.2295971512794495e-01*h1_dc_9 + -1.2547209858894348e-01*h1_dc_10 + 2.252064049243927e-01*h1_dc_11 + -2.4293405935168266e-02*h1_dc_12 + 1.3281469233334064e-02*h1_dc_13 + -4.442827105522156e-01*h1_dc_14 + 2.533000148832798e-02*h1_dc_15 + 3.114034831523895e-01;
    gi = 0.5*(h2_dc_1)*(1 + tanh(0.7978845608*((h2_dc_1) + 0.044715*(h2_dc_1)*(h2_dc_1)*(h2_dc_1)))); h2_dc_1 = gi;
    h2_dc_2 = -2.146025002002716e-01*h1_dc_0 + -3.1186020001769066e-02*h1_dc_1 + -1.8959356844425201e-01*h1_dc_2 + -1.4933368563652039e-01*h1_dc_3 + -2.329774647951126e-01*h1_dc_4 + 2.828201651573181e-01*h1_dc_5 + 3.978222906589508e-01*h1_dc_6 + -4.430272877216339e-01*h1_dc_7 + -9.563654661178589e-02*h1_dc_8 + -5.622080564498901e-01*h1_dc_9 + 5.956414341926575e-01*h1_dc_10 + -6.783320754766464e-02*h1_dc_11 + -2.4167732894420624e-01*h1_dc_12 + -3.9047929644584656e-01*h1_dc_13 + -1.4471054077148438e-01*h1_dc_14 + 1.7771971225738525e-01*h1_dc_15 + 1.6079826280474663e-02;
    gi = 0.5*(h2_dc_2)*(1 + tanh(0.7978845608*((h2_dc_2) + 0.044715*(h2_dc_2)*(h2_dc_2)*(h2_dc_2)))); h2_dc_2 = gi;
    h2_dc_3 = 1.410975158214569e-01*h1_dc_0 + 1.1863460391759872e-01*h1_dc_1 + 2.0292982459068298e-01*h1_dc_2 + -8.79843682050705e-02*h1_dc_3 + -2.534371316432953e-01*h1_dc_4 + 5.44671006500721e-02*h1_dc_5 + -1.519026905298233e-01*h1_dc_6 + -6.401463598012924e-02*h1_dc_7 + -1.292063593864441e-01*h1_dc_8 + -1.5419648587703705e-01*h1_dc_9 + 2.2690404951572418e-01*h1_dc_10 + -3.313959240913391e-01*h1_dc_11 + 1.2393323332071304e-01*h1_dc_12 + 7.925116457045078e-03*h1_dc_13 + -3.585335910320282e-01*h1_dc_14 + 9.006916731595993e-02*h1_dc_15 + 1.4627571403980255e-01;
    gi = 0.5*(h2_dc_3)*(1 + tanh(0.7978845608*((h2_dc_3) + 0.044715*(h2_dc_3)*(h2_dc_3)*(h2_dc_3)))); h2_dc_3 = gi;
    h2_dc_4 = -2.1526964008808136e-01*h1_dc_0 + -9.522580355405807e-02*h1_dc_1 + -2.761847972869873e-01*h1_dc_2 + -2.655705213546753e-01*h1_dc_3 + 9.766975790262222e-02*h1_dc_4 + 4.3305718898773193e-01*h1_dc_5 + 7.005242705345154e-01*h1_dc_6 + 2.517438232898712e-01*h1_dc_7 + 4.1449663043022156e-01*h1_dc_8 + -1.9013385474681854e-01*h1_dc_9 + 3.390921354293823e-01*h1_dc_10 + 4.956846833229065e-01*h1_dc_11 + -2.348935604095459e-01*h1_dc_12 + -5.334562063217163e-01*h1_dc_13 + 2.2386685013771057e-01*h1_dc_14 + -1.360692735761404e-02*h1_dc_15 + 6.631764024496078e-02;
    gi = 0.5*(h2_dc_4)*(1 + tanh(0.7978845608*((h2_dc_4) + 0.044715*(h2_dc_4)*(h2_dc_4)*(h2_dc_4)))); h2_dc_4 = gi;
    h2_dc_5 = -8.231399953365326e-02*h1_dc_0 + 2.442464679479599e-01*h1_dc_1 + -2.2675438225269318e-01*h1_dc_2 + 4.2628467082977295e-02*h1_dc_3 + -2.6290369033813477e-01*h1_dc_4 + -1.1475490033626556e-01*h1_dc_5 + 4.2232874035835266e-01*h1_dc_6 + -3.8395956158638e-01*h1_dc_7 + 2.6164809241890907e-03*h1_dc_8 + -8.856972679495811e-03*h1_dc_9 + -2.7639172971248627e-02*h1_dc_10 + 3.5051873326301575e-01*h1_dc_11 + 1.2218187749385834e-01*h1_dc_12 + -3.3039742708206177e-01*h1_dc_13 + -5.278406143188477e-01*h1_dc_14 + -2.1210286021232605e-01*h1_dc_15 + -1.417907029390335e-01;
    gi = 0.5*(h2_dc_5)*(1 + tanh(0.7978845608*((h2_dc_5) + 0.044715*(h2_dc_5)*(h2_dc_5)*(h2_dc_5)))); h2_dc_5 = gi;
    h2_dc_6 = -2.9790082573890686e-01*h1_dc_0 + 4.94743287563324e-02*h1_dc_1 + -1.7334648966789246e-01*h1_dc_2 + 1.6412657499313354e-01*h1_dc_3 + -3.714412748813629e-01*h1_dc_4 + -3.6156296730041504e-01*h1_dc_5 + 2.775852382183075e-01*h1_dc_6 + -9.477909654378891e-02*h1_dc_7 + 9.902399778366089e-02*h1_dc_8 + -2.1839280426502228e-01*h1_dc_9 + 2.928586006164551e-01*h1_dc_10 + 2.7574726939201355e-01*h1_dc_11 + -1.8306498229503632e-01*h1_dc_12 + -2.6532819494605064e-02*h1_dc_13 + -5.766205722466111e-04*h1_dc_14 + -1.7084717750549316e-01*h1_dc_15 + 1.7033344134688377e-02;
    gi = 0.5*(h2_dc_6)*(1 + tanh(0.7978845608*((h2_dc_6) + 0.044715*(h2_dc_6)*(h2_dc_6)*(h2_dc_6)))); h2_dc_6 = gi;
    h2_dc_7 = 2.643938362598419e-01*h1_dc_0 + 1.4754345174878836e-03*h1_dc_1 + 1.9052307307720184e-01*h1_dc_2 + 2.2766483947634697e-02*h1_dc_3 + 3.0130377411842346e-01*h1_dc_4 + -7.520439103245735e-03*h1_dc_5 + -9.152692556381226e-01*h1_dc_6 + 4.3240365386009216e-01*h1_dc_7 + -3.458680585026741e-02*h1_dc_8 + 3.4169936180114746e-01*h1_dc_9 + -6.35808527469635e-01*h1_dc_10 + -1.0862008482217789e-01*h1_dc_11 + 7.444025482982397e-03*h1_dc_12 + 3.7451988458633423e-01*h1_dc_13 + 6.536821126937866e-01*h1_dc_14 + 2.4096819758415222e-01*h1_dc_15 + -2.93927937746048e-01;
    gi = 0.5*(h2_dc_7)*(1 + tanh(0.7978845608*((h2_dc_7) + 0.044715*(h2_dc_7)*(h2_dc_7)*(h2_dc_7)))); h2_dc_7 = gi;
    h2_dc_8 = -2.851088298484683e-03*h1_dc_0 + 5.864506587386131e-03*h1_dc_1 + -4.009419083595276e-01*h1_dc_2 + -7.558962795883417e-03*h1_dc_3 + 1.600402295589447e-01*h1_dc_4 + -1.5302392840385437e-01*h1_dc_5 + -4.884878918528557e-02*h1_dc_6 + 2.2557391226291656e-01*h1_dc_7 + 1.6317127645015717e-01*h1_dc_8 + -2.3623116314411163e-01*h1_dc_9 + -3.155786097049713e-01*h1_dc_10 + 6.350239366292953e-02*h1_dc_11 + -1.1340989917516708e-01*h1_dc_12 + -1.1662989109754562e-01*h1_dc_13 + -6.328324973583221e-02*h1_dc_14 + 3.0646276473999023e-01*h1_dc_15 + 2.9104501008987427e-01;
    gi = 0.5*(h2_dc_8)*(1 + tanh(0.7978845608*((h2_dc_8) + 0.044715*(h2_dc_8)*(h2_dc_8)*(h2_dc_8)))); h2_dc_8 = gi;
    h2_dc_9 = 8.541440963745117e-02*h1_dc_0 + 3.7176868319511414e-01*h1_dc_1 + -4.052487388253212e-02*h1_dc_2 + 2.3902784287929535e-01*h1_dc_3 + 1.38532355427742e-01*h1_dc_4 + -2.3487895727157593e-01*h1_dc_5 + -1.2368319183588028e-01*h1_dc_6 + -3.813556432723999e-01*h1_dc_7 + 4.670287296175957e-02*h1_dc_8 + 3.0154338479042053e-01*h1_dc_9 + -5.414164662361145e-01*h1_dc_10 + -1.526123732328415e-01*h1_dc_11 + 6.872109770774841e-01*h1_dc_12 + -9.430024772882462e-02*h1_dc_13 + 1.0021279752254486e-01*h1_dc_14 + -1.3546082377433777e-01*h1_dc_15 + -1.6054819524288177e-01;
    gi = 0.5*(h2_dc_9)*(1 + tanh(0.7978845608*((h2_dc_9) + 0.044715*(h2_dc_9)*(h2_dc_9)*(h2_dc_9)))); h2_dc_9 = gi;
    h2_dc_10 = 3.3628083765506744e-02*h1_dc_0 + -2.4088813364505768e-01*h1_dc_1 + 3.581739664077759e-01*h1_dc_2 + -1.2959612905979156e-01*h1_dc_3 + 8.792061358690262e-02*h1_dc_4 + -2.0279908180236816e-01*h1_dc_5 + -5.672520399093628e-01*h1_dc_6 + 1.757989078760147e-01*h1_dc_7 + -1.8310314416885376e-01*h1_dc_8 + 3.047209680080414e-01*h1_dc_9 + -3.0467385053634644e-01*h1_dc_10 + -1.34203240275383e-01*h1_dc_11 + 4.705429449677467e-02*h1_dc_12 + 2.0895032584667206e-01*h1_dc_13 + 3.679004907608032e-01*h1_dc_14 + 7.511341571807861e-02*h1_dc_15 + -5.608878135681152e-01;
    gi = 0.5*(h2_dc_10)*(1 + tanh(0.7978845608*((h2_dc_10) + 0.044715*(h2_dc_10)*(h2_dc_10)*(h2_dc_10)))); h2_dc_10 = gi;
    h2_dc_11 = 1.1896159499883652e-02*h1_dc_0 + 1.9981853663921356e-01*h1_dc_1 + 4.6222272515296936e-01*h1_dc_2 + 2.6699888706207275e-01*h1_dc_3 + -3.572026491165161e-01*h1_dc_4 + 4.856225550174713e-01*h1_dc_5 + -3.140053451061249e-01*h1_dc_6 + 5.266205593943596e-02*h1_dc_7 + 1.4679774641990662e-01*h1_dc_8 + 4.620930552482605e-01*h1_dc_9 + 1.796051561832428e-01*h1_dc_10 + -1.28282368183136e-01*h1_dc_11 + 1.6471829265356064e-02*h1_dc_12 + 5.319340229034424e-01*h1_dc_13 + -9.062308073043823e-02*h1_dc_14 + -8.458338677883148e-02*h1_dc_15 + 7.027027755975723e-02;
    gi = 0.5*(h2_dc_11)*(1 + tanh(0.7978845608*((h2_dc_11) + 0.044715*(h2_dc_11)*(h2_dc_11)*(h2_dc_11)))); h2_dc_11 = gi;
    h2_dc_12 = -1.9773678481578827e-01*h1_dc_0 + -1.4813083410263062e-01*h1_dc_1 + -1.96810781955719e-01*h1_dc_2 + 4.781484305858612e-01*h1_dc_3 + -5.189328268170357e-02*h1_dc_4 + 7.781749963760376e-02*h1_dc_5 + 3.6825355887413025e-01*h1_dc_6 + 5.066625401377678e-02*h1_dc_7 + 6.938162446022034e-02*h1_dc_8 + 6.413856148719788e-02*h1_dc_9 + 1.520835142582655e-02*h1_dc_10 + 4.967649281024933e-01*h1_dc_11 + -1.6352982819080353e-01*h1_dc_12 + 1.079983115196228e-01*h1_dc_13 + -2.64728844165802e-01*h1_dc_14 + -1.493289414793253e-02*h1_dc_15 + 1.0052327811717987e-01;
    gi = 0.5*(h2_dc_12)*(1 + tanh(0.7978845608*((h2_dc_12) + 0.044715*(h2_dc_12)*(h2_dc_12)*(h2_dc_12)))); h2_dc_12 = gi;
    h2_dc_13 = 1.4953599870204926e-01*h1_dc_0 + 7.661724090576172e-02*h1_dc_1 + -7.568114995956421e-02*h1_dc_2 + -4.9344923347234726e-02*h1_dc_3 + -2.0820774137973785e-01*h1_dc_4 + 6.534493714570999e-02*h1_dc_5 + -1.715700477361679e-01*h1_dc_6 + -3.63907128572464e-01*h1_dc_7 + -4.662182927131653e-01*h1_dc_8 + -1.7193815112113953e-01*h1_dc_9 + 7.659132778644562e-02*h1_dc_10 + 2.803216688334942e-02*h1_dc_11 + 2.148410677909851e-01*h1_dc_12 + -2.5090712308883667e-01*h1_dc_13 + -2.3599675297737122e-01*h1_dc_14 + -1.063465103507042e-01*h1_dc_15 + 2.877855598926544e-01;
    gi = 0.5*(h2_dc_13)*(1 + tanh(0.7978845608*((h2_dc_13) + 0.044715*(h2_dc_13)*(h2_dc_13)*(h2_dc_13)))); h2_dc_13 = gi;
    h2_dc_14 = 1.3911688327789307e-01*h1_dc_0 + -2.737480103969574e-01*h1_dc_1 + -5.468745157122612e-02*h1_dc_2 + 1.57207190990448e-01*h1_dc_3 + -1.3619814813137054e-01*h1_dc_4 + 3.611351251602173e-01*h1_dc_5 + -3.0381321907043457e-01*h1_dc_6 + -8.972868323326111e-02*h1_dc_7 + 4.5364058017730713e-01*h1_dc_8 + 1.922905147075653e-01*h1_dc_9 + 2.0863038301467896e-01*h1_dc_10 + -3.167067766189575e-01*h1_dc_11 + 9.093431383371353e-02*h1_dc_12 + 2.6512330770492554e-01*h1_dc_13 + -1.1760180443525314e-01*h1_dc_14 + 3.369406461715698e-01*h1_dc_15 + -1.5908516943454742e-01;
    gi = 0.5*(h2_dc_14)*(1 + tanh(0.7978845608*((h2_dc_14) + 0.044715*(h2_dc_14)*(h2_dc_14)*(h2_dc_14)))); h2_dc_14 = gi;
    h2_dc_15 = 1.3098326325416565e-01*h1_dc_0 + -1.89582958817482e-01*h1_dc_1 + 5.723702162504196e-02*h1_dc_2 + -1.7585240304470062e-01*h1_dc_3 + -9.39425528049469e-02*h1_dc_4 + 3.2792919874191284e-01*h1_dc_5 + 6.284942477941513e-02*h1_dc_6 + -5.34633994102478e-01*h1_dc_7 + 2.4787099659442902e-01*h1_dc_8 + -2.0675206184387207e-01*h1_dc_9 + 7.50277191400528e-02*h1_dc_10 + -4.3099869042634964e-02*h1_dc_11 + 2.055782526731491e-01*h1_dc_12 + 4.4572514295578003e-01*h1_dc_13 + -3.90498548746109e-01*h1_dc_14 + 1.5738941729068756e-01*h1_dc_15 + 2.4058157205581665e-01;
    gi = 0.5*(h2_dc_15)*(1 + tanh(0.7978845608*((h2_dc_15) + 0.044715*(h2_dc_15)*(h2_dc_15)*(h2_dc_15)))); h2_dc_15 = gi;
    h2_dc_16 = -6.309674978256226e-01*h1_dc_0 + 3.689146414399147e-02*h1_dc_1 + 4.250441677868366e-03*h1_dc_2 + -1.280125081539154e-01*h1_dc_3 + -2.496977597475052e-01*h1_dc_4 + 1.3375695049762726e-01*h1_dc_5 + 7.262765616178513e-02*h1_dc_6 + 5.114375352859497e-01*h1_dc_7 + -1.062808409333229e-01*h1_dc_8 + 3.0346181988716125e-01*h1_dc_9 + -3.634265065193176e-01*h1_dc_10 + -4.700725898146629e-02*h1_dc_11 + 1.2932857871055603e-01*h1_dc_12 + -1.3128891587257385e-01*h1_dc_13 + 2.1350006759166718e-01*h1_dc_14 + -2.873953878879547e-01*h1_dc_15 + -8.468953520059586e-02;
    gi = 0.5*(h2_dc_16)*(1 + tanh(0.7978845608*((h2_dc_16) + 0.044715*(h2_dc_16)*(h2_dc_16)*(h2_dc_16)))); h2_dc_16 = gi;
    h2_dc_17 = 4.8636503517627716e-02*h1_dc_0 + -6.069091558456421e-01*h1_dc_1 + 1.5179716050624847e-01*h1_dc_2 + -1.1087947338819504e-01*h1_dc_3 + 8.148479461669922e-02*h1_dc_4 + -2.649442255496979e-01*h1_dc_5 + 1.6427747905254364e-02*h1_dc_6 + 3.521203100681305e-01*h1_dc_7 + 7.103705406188965e-02*h1_dc_8 + 7.741798181086779e-04*h1_dc_9 + 1.7784346640110016e-01*h1_dc_10 + -9.847743809223175e-02*h1_dc_11 + -4.133366048336029e-01*h1_dc_12 + -2.6966333389282227e-01*h1_dc_13 + -6.319913268089294e-01*h1_dc_14 + 3.8739997148513794e-01*h1_dc_15 + 1.062450110912323e-01;
    gi = 0.5*(h2_dc_17)*(1 + tanh(0.7978845608*((h2_dc_17) + 0.044715*(h2_dc_17)*(h2_dc_17)*(h2_dc_17)))); h2_dc_17 = gi;
    h2_dc_18 = -7.384943217039108e-02*h1_dc_0 + -1.611531525850296e-01*h1_dc_1 + -4.9231433868408203e-01*h1_dc_2 + -4.997366666793823e-02*h1_dc_3 + -9.560177475214005e-02*h1_dc_4 + 6.886440794914961e-03*h1_dc_5 + 1.516171544790268e-01*h1_dc_6 + 1.5455350279808044e-01*h1_dc_7 + -4.2964497208595276e-01*h1_dc_8 + 3.5755857825279236e-01*h1_dc_9 + 3.2569173723459244e-02*h1_dc_10 + -1.5664921700954437e-01*h1_dc_11 + 1.7388421297073364e-01*h1_dc_12 + 6.71360120177269e-02*h1_dc_13 + 3.962002992630005e-01*h1_dc_14 + 1.293017864227295e-01*h1_dc_15 + -2.2561239078640938e-02;
    gi = 0.5*(h2_dc_18)*(1 + tanh(0.7978845608*((h2_dc_18) + 0.044715*(h2_dc_18)*(h2_dc_18)*(h2_dc_18)))); h2_dc_18 = gi;
    h2_dc_19 = -9.27092507481575e-02*h1_dc_0 + -2.3449169099330902e-01*h1_dc_1 + -3.544141352176666e-01*h1_dc_2 + 7.926152348518372e-01*h1_dc_3 + -3.3621013164520264e-01*h1_dc_4 + -3.6705175042152405e-01*h1_dc_5 + -9.954153001308441e-02*h1_dc_6 + -2.629687488079071e-01*h1_dc_7 + 1.0765049606561661e-01*h1_dc_8 + 1.3081394135951996e-01*h1_dc_9 + 7.240772247314453e-02*h1_dc_10 + 4.936988279223442e-02*h1_dc_11 + -1.3580258190631866e-01*h1_dc_12 + 6.090571638196707e-03*h1_dc_13 + -1.7495833337306976e-01*h1_dc_14 + 6.195646524429321e-02*h1_dc_15 + 2.713358700275421e-01;
    gi = 0.5*(h2_dc_19)*(1 + tanh(0.7978845608*((h2_dc_19) + 0.044715*(h2_dc_19)*(h2_dc_19)*(h2_dc_19)))); h2_dc_19 = gi;
    h2_dc_20 = 4.9436137080192566e-02*h1_dc_0 + 1.2046351432800293e+00*h1_dc_1 + 7.371368259191513e-02*h1_dc_2 + 1.2075440585613251e-01*h1_dc_3 + -6.744380593299866e-01*h1_dc_4 + 5.153053998947144e-01*h1_dc_5 + 5.603997707366943e-01*h1_dc_6 + -3.449924886226654e-01*h1_dc_7 + -2.2062323987483978e-01*h1_dc_8 + -6.98561891913414e-02*h1_dc_9 + -1.0324999690055847e-01*h1_dc_10 + 5.196396112442017e-01*h1_dc_11 + 6.217430233955383e-01*h1_dc_12 + -2.954452335834503e-01*h1_dc_13 + -5.850386992096901e-02*h1_dc_14 + -4.1742420196533203e-01*h1_dc_15 + -5.14289140701294e-01;
    gi = 0.5*(h2_dc_20)*(1 + tanh(0.7978845608*((h2_dc_20) + 0.044715*(h2_dc_20)*(h2_dc_20)*(h2_dc_20)))); h2_dc_20 = gi;
    h2_dc_21 = -2.563663721084595e-01*h1_dc_0 + -3.114728331565857e-01*h1_dc_1 + 1.6400688886642456e-01*h1_dc_2 + 5.666245520114899e-02*h1_dc_3 + -1.6983620822429657e-02*h1_dc_4 + 1.502884030342102e-01*h1_dc_5 + 2.4520394206047058e-01*h1_dc_6 + -4.711807370185852e-01*h1_dc_7 + -3.2327792048454285e-01*h1_dc_8 + 1.219729483127594e-01*h1_dc_9 + -5.6268833577632904e-02*h1_dc_10 + 2.4924308061599731e-01*h1_dc_11 + -2.041269689798355e-01*h1_dc_12 + 3.479123115539551e-02*h1_dc_13 + -3.016416132450104e-01*h1_dc_14 + -3.292664512991905e-02*h1_dc_15 + 7.068273425102234e-02;
    gi = 0.5*(h2_dc_21)*(1 + tanh(0.7978845608*((h2_dc_21) + 0.044715*(h2_dc_21)*(h2_dc_21)*(h2_dc_21)))); h2_dc_21 = gi;
    h2_dc_22 = -1.2583713233470917e-01*h1_dc_0 + -2.2096876800060272e-01*h1_dc_1 + -7.375173270702362e-02*h1_dc_2 + 1.6001728177070618e-01*h1_dc_3 + -2.3649682104587555e-01*h1_dc_4 + 5.989662930369377e-02*h1_dc_5 + -1.4939577877521515e-01*h1_dc_6 + -1.6651752591133118e-01*h1_dc_7 + -1.612890362739563e-01*h1_dc_8 + -7.223764806985855e-02*h1_dc_9 + 1.1915481835603714e-01*h1_dc_10 + -1.0328463464975357e-01*h1_dc_11 + -3.633335828781128e-01*h1_dc_12 + 1.504647582769394e-01*h1_dc_13 + -2.6229289174079895e-01*h1_dc_14 + -1.0489894449710846e-01*h1_dc_15 + 2.5478053092956543e-01;
    gi = 0.5*(h2_dc_22)*(1 + tanh(0.7978845608*((h2_dc_22) + 0.044715*(h2_dc_22)*(h2_dc_22)*(h2_dc_22)))); h2_dc_22 = gi;
    h2_dc_23 = 1.5083861351013184e-01*h1_dc_0 + 6.084851026535034e-01*h1_dc_1 + 8.445261977612972e-03*h1_dc_2 + 1.3196289539337158e-01*h1_dc_3 + -1.2681923806667328e-01*h1_dc_4 + -5.639116764068604e-01*h1_dc_5 + -2.2778038680553436e-01*h1_dc_6 + 1.3562189042568207e-01*h1_dc_7 + -2.1408244967460632e-01*h1_dc_8 + -1.940031535923481e-02*h1_dc_9 + -8.344418555498123e-02*h1_dc_10 + -1.4055438339710236e-01*h1_dc_11 + 5.561674237251282e-01*h1_dc_12 + -3.318850323557854e-02*h1_dc_13 + -1.674848608672619e-02*h1_dc_14 + 5.0456054508686066e-02*h1_dc_15 + -1.3861645758152008e-01;
    gi = 0.5*(h2_dc_23)*(1 + tanh(0.7978845608*((h2_dc_23) + 0.044715*(h2_dc_23)*(h2_dc_23)*(h2_dc_23)))); h2_dc_23 = gi;
    h2_dc_24 = -2.6039648056030273e-01*h1_dc_0 + 3.822344243526459e-01*h1_dc_1 + 1.1869760230183601e-02*h1_dc_2 + 3.245305269956589e-02*h1_dc_3 + -2.2441135719418526e-02*h1_dc_4 + 1.533837467432022e-01*h1_dc_5 + 2.2130292654037476e-01*h1_dc_6 + 1.7399808764457703e-01*h1_dc_7 + 7.390238344669342e-02*h1_dc_8 + -5.295661687850952e-01*h1_dc_9 + -2.2750712931156158e-01*h1_dc_10 + -1.1330234259366989e-01*h1_dc_11 + 3.080025911331177e-01*h1_dc_12 + 5.36790668964386e-01*h1_dc_13 + -8.082131296396255e-02*h1_dc_14 + -1.341833919286728e-01*h1_dc_15 + -2.0940841734409332e-01;
    gi = 0.5*(h2_dc_24)*(1 + tanh(0.7978845608*((h2_dc_24) + 0.044715*(h2_dc_24)*(h2_dc_24)*(h2_dc_24)))); h2_dc_24 = gi;
    h2_dc_25 = 2.7597951889038086e-01*h1_dc_0 + 1.1569701135158539e-01*h1_dc_1 + 4.014393985271454e-01*h1_dc_2 + -1.894521415233612e-01*h1_dc_3 + -1.0445728152990341e-01*h1_dc_4 + -1.9850345328450203e-02*h1_dc_5 + 1.4490732550621033e-01*h1_dc_6 + 1.4303584396839142e-01*h1_dc_7 + 1.331228669732809e-02*h1_dc_8 + 3.0117231607437134e-01*h1_dc_9 + 4.501791670918465e-02*h1_dc_10 + 2.005244642496109e-01*h1_dc_11 + 5.56979238986969e-01*h1_dc_12 + -4.19838547706604e-01*h1_dc_13 + -2.514564096927643e-01*h1_dc_14 + -8.721417188644409e-02*h1_dc_15 + -1.2570558488368988e-01;
    gi = 0.5*(h2_dc_25)*(1 + tanh(0.7978845608*((h2_dc_25) + 0.044715*(h2_dc_25)*(h2_dc_25)*(h2_dc_25)))); h2_dc_25 = gi;
    h2_dc_26 = -8.584625273942947e-02*h1_dc_0 + -1.2123094499111176e-01*h1_dc_1 + -1.7905719578266144e-01*h1_dc_2 + -2.53152996301651e-01*h1_dc_3 + -3.3693641424179077e-01*h1_dc_4 + -1.316031813621521e-01*h1_dc_5 + 1.3730326294898987e-01*h1_dc_6 + -1.723962277173996e-01*h1_dc_7 + -3.041979670524597e-02*h1_dc_8 + -3.9020997285842896e-01*h1_dc_9 + 3.476169193163514e-03*h1_dc_10 + 5.132615938782692e-02*h1_dc_11 + -3.2319390773773193e-01*h1_dc_12 + -4.6721406280994415e-02*h1_dc_13 + -7.1928431279957294e-03*h1_dc_14 + 9.393608570098877e-02*h1_dc_15 + -1.0666695237159729e-01;
    gi = 0.5*(h2_dc_26)*(1 + tanh(0.7978845608*((h2_dc_26) + 0.044715*(h2_dc_26)*(h2_dc_26)*(h2_dc_26)))); h2_dc_26 = gi;
    h2_dc_27 = -4.9867164343595505e-02*h1_dc_0 + -4.1865983605384827e-01*h1_dc_1 + -2.7293333411216736e-01*h1_dc_2 + 4.837646782398224e-01*h1_dc_3 + 8.775721490383148e-02*h1_dc_4 + -8.604741096496582e-02*h1_dc_5 + 2.4762563407421112e-01*h1_dc_6 + -1.9752801954746246e-01*h1_dc_7 + 4.2481446266174316e-01*h1_dc_8 + -1.5194669365882874e-01*h1_dc_9 + -1.7528212070465088e-01*h1_dc_10 + 2.51396507024765e-01*h1_dc_11 + -7.434307336807251e-01*h1_dc_12 + 3.2136181835085154e-03*h1_dc_13 + 4.270418584346771e-01*h1_dc_14 + -4.995594173669815e-02*h1_dc_15 + 1.7571213841438293e-01;
    gi = 0.5*(h2_dc_27)*(1 + tanh(0.7978845608*((h2_dc_27) + 0.044715*(h2_dc_27)*(h2_dc_27)*(h2_dc_27)))); h2_dc_27 = gi;
    h2_dc_28 = -9.932083636522293e-02*h1_dc_0 + -2.5602981448173523e-01*h1_dc_1 + -7.331886142492294e-02*h1_dc_2 + -4.078335165977478e-01*h1_dc_3 + -1.5586800873279572e-01*h1_dc_4 + 5.190824866294861e-01*h1_dc_5 + 1.3655804097652435e-01*h1_dc_6 + -2.0978188514709473e-01*h1_dc_7 + 1.065460741519928e-01*h1_dc_8 + -1.8016238510608673e-01*h1_dc_9 + 3.096713721752167e-01*h1_dc_10 + 2.688192129135132e-01*h1_dc_11 + 2.9276488348841667e-02*h1_dc_12 + 5.0873901695013046e-02*h1_dc_13 + -5.368782877922058e-01*h1_dc_14 + 5.1592253148555756e-03*h1_dc_15 + 2.430771291255951e-01;
    gi = 0.5*(h2_dc_28)*(1 + tanh(0.7978845608*((h2_dc_28) + 0.044715*(h2_dc_28)*(h2_dc_28)*(h2_dc_28)))); h2_dc_28 = gi;
    h2_dc_29 = 1.1644355952739716e-01*h1_dc_0 + 1.5432673692703247e-01*h1_dc_1 + 1.8934455513954163e-01*h1_dc_2 + -1.8466906249523163e-01*h1_dc_3 + -8.970963954925537e-02*h1_dc_4 + 5.613593459129333e-01*h1_dc_5 + 3.917922452092171e-02*h1_dc_6 + 1.635165512561798e-02*h1_dc_7 + -1.8980468809604645e-01*h1_dc_8 + -2.5752559304237366e-01*h1_dc_9 + 1.3501428067684174e-01*h1_dc_10 + -2.1376121044158936e-01*h1_dc_11 + 1.9879202544689178e-01*h1_dc_12 + -5.059505701065063e-01*h1_dc_13 + 4.0496447682380676e-01*h1_dc_14 + 1.8612289428710938e-01*h1_dc_15 + 2.5217482447624207e-01;
    gi = 0.5*(h2_dc_29)*(1 + tanh(0.7978845608*((h2_dc_29) + 0.044715*(h2_dc_29)*(h2_dc_29)*(h2_dc_29)))); h2_dc_29 = gi;
    h2_dc_30 = 1.1704649031162262e-01*h1_dc_0 + 4.026891589164734e-01*h1_dc_1 + 1.846589893102646e-01*h1_dc_2 + -7.954631000757217e-02*h1_dc_3 + -4.180322289466858e-01*h1_dc_4 + -2.063271589577198e-02*h1_dc_5 + -7.478857785463333e-02*h1_dc_6 + 5.090051889419556e-01*h1_dc_7 + -2.4147650599479675e-01*h1_dc_8 + 3.063061833381653e-02*h1_dc_9 + -9.376115049235523e-04*h1_dc_10 + -3.0169013887643814e-02*h1_dc_11 + 1.054152250289917e+00*h1_dc_12 + 2.4128980934619904e-01*h1_dc_13 + -2.22235307097435e-01*h1_dc_14 + 2.891632616519928e-01*h1_dc_15 + -3.356853425502777e-01;
    gi = 0.5*(h2_dc_30)*(1 + tanh(0.7978845608*((h2_dc_30) + 0.044715*(h2_dc_30)*(h2_dc_30)*(h2_dc_30)))); h2_dc_30 = gi;
    h2_dc_31 = -7.98126608133316e-02*h1_dc_0 + -3.6076851189136505e-02*h1_dc_1 + 1.859932243824005e-01*h1_dc_2 + -2.01840341091156e-01*h1_dc_3 + 2.2699913382530212e-01*h1_dc_4 + 5.577804520726204e-02*h1_dc_5 + -3.6551833152770996e-01*h1_dc_6 + 3.546246290206909e-01*h1_dc_7 + 4.008031487464905e-01*h1_dc_8 + 5.910988450050354e-01*h1_dc_9 + -3.5224464535713196e-01*h1_dc_10 + -3.516860008239746e-01*h1_dc_11 + -2.3314990103244781e-01*h1_dc_12 + 2.892626225948334e-01*h1_dc_13 + -1.1054348200559616e-02*h1_dc_14 + 4.000515937805176e-01*h1_dc_15 + -1.5491580590605736e-02;
    gi = 0.5*(h2_dc_31)*(1 + tanh(0.7978845608*((h2_dc_31) + 0.044715*(h2_dc_31)*(h2_dc_31)*(h2_dc_31)))); h2_dc_31 = gi;
    h3_dc_0 = 1.5220721065998077e-01*h2_dc_0 + 1.8917451798915863e-01*h2_dc_1 + 2.048131823539734e-02*h2_dc_2 + 4.769231081008911e-01*h2_dc_3 + 4.264252185821533e-01*h2_dc_4 + -3.9456769824028015e-01*h2_dc_5 + -2.973751723766327e-01*h2_dc_6 + -3.545323610305786e-01*h2_dc_7 + 4.559597969055176e-01*h2_dc_8 + -5.283874869346619e-01*h2_dc_9 + -7.156368810683489e-03*h2_dc_10 + 4.215538799762726e-01*h2_dc_11 + -2.897249460220337e-01*h2_dc_12 + 2.3999132215976715e-01*h2_dc_13 + -2.2178180515766144e-01*h2_dc_14 + 5.044090747833252e-01*h2_dc_15 + 2.3182688653469086e-01*h2_dc_16 + 2.4231991171836853e-01*h2_dc_17 + -2.3198792710900307e-02*h2_dc_18 + 1.8415451049804688e-01*h2_dc_19 + 4.6772652864456177e-01*h2_dc_20 + 3.152931034564972e-01*h2_dc_21 + 1.3685236871242523e-01*h2_dc_22 + -4.0979135036468506e-01*h2_dc_23 + -3.518906235694885e-01*h2_dc_24 + 1.5350791811943054e-01*h2_dc_25 + 1.0643617063760757e-01*h2_dc_26 + -1.6036158800125122e-01*h2_dc_27 + 3.310047686100006e-01*h2_dc_28 + 2.0832137763500214e-01*h2_dc_29 + 3.873334228992462e-01*h2_dc_30 + 1.9350115954875946e-01*h2_dc_31 + 1.6226717829704285e-01;
    gi = 0.5*(h3_dc_0)*(1 + tanh(0.7978845608*((h3_dc_0) + 0.044715*(h3_dc_0)*(h3_dc_0)*(h3_dc_0)))); h3_dc_0 = gi;
    h3_dc_1 = 1.275121569633484e-01*h2_dc_0 + 3.506944477558136e-01*h2_dc_1 + -5.605631321668625e-02*h2_dc_2 + -1.495111733675003e-01*h2_dc_3 + 2.575601637363434e-02*h2_dc_4 + 6.871873885393143e-02*h2_dc_5 + 3.826791048049927e-01*h2_dc_6 + -5.070715397596359e-02*h2_dc_7 + -3.3525869250297546e-01*h2_dc_8 + -3.443582057952881e-01*h2_dc_9 + -2.882940471172333e-01*h2_dc_10 + -6.898622214794159e-02*h2_dc_11 + 2.1555133163928986e-01*h2_dc_12 + -4.938456788659096e-02*h2_dc_13 + 9.909343719482422e-02*h2_dc_14 + -1.653277724981308e-01*h2_dc_15 + -6.1080947518348694e-02*h2_dc_16 + 1.0079330950975418e-01*h2_dc_17 + 4.968086630105972e-02*h2_dc_18 + -1.9346067309379578e-01*h2_dc_19 + -4.693647846579552e-03*h2_dc_20 + 3.456457331776619e-02*h2_dc_21 + 2.884070873260498e-01*h2_dc_22 + 1.3858133554458618e-01*h2_dc_23 + 3.1561221927404404e-02*h2_dc_24 + -1.4057940244674683e-01*h2_dc_25 + -3.207864984869957e-02*h2_dc_26 + -1.4323844015598297e-01*h2_dc_27 + -2.934408187866211e-01*h2_dc_28 + -1.9782961905002594e-01*h2_dc_29 + 1.7837991937994957e-02*h2_dc_30 + 2.9142963886260986e-01*h2_dc_31 + 6.326908469200134e-01;
    gi = 0.5*(h3_dc_1)*(1 + tanh(0.7978845608*((h3_dc_1) + 0.044715*(h3_dc_1)*(h3_dc_1)*(h3_dc_1)))); h3_dc_1 = gi;
    h3_dc_2 = 3.527311384677887e-01*h2_dc_0 + 1.4211028814315796e-01*h2_dc_1 + -4.7069841623306274e-01*h2_dc_2 + -3.2065096497535706e-01*h2_dc_3 + -9.33496281504631e-02*h2_dc_4 + 7.945673540234566e-03*h2_dc_5 + -7.293254882097244e-02*h2_dc_6 + 2.831384837627411e-01*h2_dc_7 + 1.8783628940582275e-01*h2_dc_8 + -6.573016196489334e-02*h2_dc_9 + -1.2701056897640228e-01*h2_dc_10 + 5.125239491462708e-01*h2_dc_11 + 5.1326166838407516e-02*h2_dc_12 + 1.892886757850647e-01*h2_dc_13 + -2.4990904331207275e-01*h2_dc_14 + -1.3004449009895325e-01*h2_dc_15 + 1.2234877794981003e-01*h2_dc_16 + -3.317738696932793e-02*h2_dc_17 + 2.1778231859207153e-01*h2_dc_18 + 9.033159166574478e-02*h2_dc_19 + 3.063727617263794e-01*h2_dc_20 + 1.3011766970157623e-01*h2_dc_21 + 8.643311262130737e-02*h2_dc_22 + -1.671014130115509e-01*h2_dc_23 + 6.0433823615312576e-02*h2_dc_24 + -2.254089117050171e-01*h2_dc_25 + -5.71314811706543e-01*h2_dc_26 + 1.1830439791083336e-02*h2_dc_27 + -3.299427628517151e-01*h2_dc_28 + 2.2176237404346466e-01*h2_dc_29 + 2.3541072010993958e-01*h2_dc_30 + 3.605855107307434e-01*h2_dc_31 + 1.1186128854751587e-01;
    gi = 0.5*(h3_dc_2)*(1 + tanh(0.7978845608*((h3_dc_2) + 0.044715*(h3_dc_2)*(h3_dc_2)*(h3_dc_2)))); h3_dc_2 = gi;
    h3_dc_3 = -3.216661214828491e-01*h2_dc_0 + 4.504673555493355e-02*h2_dc_1 + 3.678314685821533e-01*h2_dc_2 + -2.656370997428894e-01*h2_dc_3 + -4.3086469173431396e-02*h2_dc_4 + 4.553656578063965e-01*h2_dc_5 + -2.31918066740036e-01*h2_dc_6 + -6.016350984573364e-01*h2_dc_7 + 1.7116288840770721e-01*h2_dc_8 + -3.0490097403526306e-01*h2_dc_9 + -4.036054015159607e-01*h2_dc_10 + 9.004398435354233e-02*h2_dc_11 + -1.4810501039028168e-01*h2_dc_12 + -5.5893149226903915e-02*h2_dc_13 + 1.157061830163002e-01*h2_dc_14 + 2.1067377924919128e-01*h2_dc_15 + 3.7592124938964844e-01*h2_dc_16 + 3.870665729045868e-01*h2_dc_17 + -1.5806615352630615e-01*h2_dc_18 + -4.2614373564720154e-01*h2_dc_19 + -4.886034429073334e-01*h2_dc_20 + -5.282379686832428e-02*h2_dc_21 + -8.07375181466341e-03*h2_dc_22 + -1.1634756810963154e-02*h2_dc_23 + 6.826622784137726e-02*h2_dc_24 + -4.633712023496628e-02*h2_dc_25 + -1.4716625213623047e-01*h2_dc_26 + -1.5574274957180023e-01*h2_dc_27 + 3.330320715904236e-01*h2_dc_28 + 3.8120731711387634e-01*h2_dc_29 + -2.3687753081321716e-01*h2_dc_30 + 5.228687822818756e-02*h2_dc_31 + 6.821299344301224e-02;
    gi = 0.5*(h3_dc_3)*(1 + tanh(0.7978845608*((h3_dc_3) + 0.044715*(h3_dc_3)*(h3_dc_3)*(h3_dc_3)))); h3_dc_3 = gi;
    h3_dc_4 = -1.6584818065166473e-01*h2_dc_0 + -2.776547968387604e-01*h2_dc_1 + 5.334475636482239e-02*h2_dc_2 + -1.3095489144325256e-01*h2_dc_3 + 9.276598691940308e-02*h2_dc_4 + -2.608695328235626e-01*h2_dc_5 + 3.400350734591484e-02*h2_dc_6 + -3.3352382481098175e-02*h2_dc_7 + -1.2325011938810349e-01*h2_dc_8 + 6.244775652885437e-01*h2_dc_9 + 1.1722517013549805e-01*h2_dc_10 + -2.0141107961535454e-02*h2_dc_11 + -2.2748224437236786e-01*h2_dc_12 + -3.8924694061279297e-01*h2_dc_13 + -3.663165271282196e-01*h2_dc_14 + 1.7237823456525803e-02*h2_dc_15 + -1.7719563841819763e-01*h2_dc_16 + 1.1320008337497711e-01*h2_dc_17 + -7.162147760391235e-02*h2_dc_18 + 2.9290544986724854e-01*h2_dc_19 + 1.9656406342983246e-01*h2_dc_20 + 2.929116487503052e-01*h2_dc_21 + 3.0791333317756653e-01*h2_dc_22 + 4.3913647532463074e-01*h2_dc_23 + 4.988214746117592e-02*h2_dc_24 + 2.736719846725464e-01*h2_dc_25 + -1.9321131706237793e-01*h2_dc_26 + 4.667232930660248e-01*h2_dc_27 + -3.4413471817970276e-01*h2_dc_28 + -2.9655447602272034e-01*h2_dc_29 + 5.470839142799377e-01*h2_dc_30 + 6.1725255101919174e-02*h2_dc_31 + -8.044212311506271e-02;
    gi = 0.5*(h3_dc_4)*(1 + tanh(0.7978845608*((h3_dc_4) + 0.044715*(h3_dc_4)*(h3_dc_4)*(h3_dc_4)))); h3_dc_4 = gi;
    h3_dc_5 = 4.337173104286194e-01*h2_dc_0 + -4.198853671550751e-01*h2_dc_1 + -3.042653203010559e-01*h2_dc_2 + -3.358827158808708e-02*h2_dc_3 + -3.115539252758026e-01*h2_dc_4 + 5.9016238898038864e-02*h2_dc_5 + 2.73255854845047e-01*h2_dc_6 + 3.7354734539985657e-01*h2_dc_7 + -1.4501060545444489e-01*h2_dc_8 + -1.3365956023335457e-02*h2_dc_9 + -2.3702877759933472e-01*h2_dc_10 + -1.0240602493286133e-01*h2_dc_11 + -1.264173835515976e-01*h2_dc_12 + -4.708138406276703e-01*h2_dc_13 + 3.6380213499069214e-01*h2_dc_14 + -2.478058785200119e-01*h2_dc_15 + -3.140110373497009e-01*h2_dc_16 + -1.97289377450943e-01*h2_dc_17 + 3.648959994316101e-01*h2_dc_18 + -1.7888785898685455e-01*h2_dc_19 + -2.640054523944855e-01*h2_dc_20 + 2.2235988080501556e-01*h2_dc_21 + -2.5275468826293945e-01*h2_dc_22 + -1.3507644832134247e-01*h2_dc_23 + 3.4693315625190735e-01*h2_dc_24 + -2.5797969102859497e-01*h2_dc_25 + 2.369111180305481e-01*h2_dc_26 + -1.8595139682292938e-01*h2_dc_27 + 2.561178207397461e-01*h2_dc_28 + -1.5392139554023743e-01*h2_dc_29 + -2.584398090839386e-01*h2_dc_30 + 3.6081910133361816e-01*h2_dc_31 + -1.1801885068416595e-01;
    gi = 0.5*(h3_dc_5)*(1 + tanh(0.7978845608*((h3_dc_5) + 0.044715*(h3_dc_5)*(h3_dc_5)*(h3_dc_5)))); h3_dc_5 = gi;
    h3_dc_6 = -2.903340458869934e-01*h2_dc_0 + -7.93517455458641e-02*h2_dc_1 + -2.5729972403496504e-03*h2_dc_2 + 3.013421297073364e-01*h2_dc_3 + 3.2230377197265625e-01*h2_dc_4 + 3.6309781670570374e-01*h2_dc_5 + 9.347817301750183e-02*h2_dc_6 + 1.7316028475761414e-01*h2_dc_7 + 3.872978687286377e-02*h2_dc_8 + -2.3710308969020844e-01*h2_dc_9 + -3.499084413051605e-01*h2_dc_10 + 5.127355828881264e-02*h2_dc_11 + -1.3127653300762177e-01*h2_dc_12 + 3.4625935554504395e-01*h2_dc_13 + 1.0655809193849564e-01*h2_dc_14 + 2.2907555103302002e-01*h2_dc_15 + 3.6502838134765625e-01*h2_dc_16 + 2.431716024875641e-01*h2_dc_17 + 2.7415215969085693e-02*h2_dc_18 + -2.3446640372276306e-01*h2_dc_19 + -6.095345616340637e-01*h2_dc_20 + 6.852911412715912e-02*h2_dc_21 + 1.8580728769302368e-01*h2_dc_22 + -1.62384033203125e-01*h2_dc_23 + 1.9459843635559082e-01*h2_dc_24 + -6.442748755216599e-02*h2_dc_25 + -1.704442799091339e-01*h2_dc_26 + -2.2442187368869781e-01*h2_dc_27 + 2.057192474603653e-01*h2_dc_28 + 2.824493944644928e-01*h2_dc_29 + -1.2126097083091736e-01*h2_dc_30 + -1.300276666879654e-01*h2_dc_31 + 5.4386756382882595e-03;
    gi = 0.5*(h3_dc_6)*(1 + tanh(0.7978845608*((h3_dc_6) + 0.044715*(h3_dc_6)*(h3_dc_6)*(h3_dc_6)))); h3_dc_6 = gi;
    h3_dc_7 = 4.494819939136505e-01*h2_dc_0 + 3.591729700565338e-02*h2_dc_1 + 1.686515063047409e-01*h2_dc_2 + -1.0720592737197876e-01*h2_dc_3 + -4.323224127292633e-01*h2_dc_4 + -8.685878664255142e-02*h2_dc_5 + -8.5470050573349e-02*h2_dc_6 + 1.8870267271995544e-01*h2_dc_7 + 1.2690305709838867e-01*h2_dc_8 + -5.853100121021271e-02*h2_dc_9 + 1.013149619102478e-01*h2_dc_10 + 2.8073856234550476e-01*h2_dc_11 + -1.3124166056513786e-02*h2_dc_12 + 1.8486786633729935e-02*h2_dc_13 + 1.96340411901474e-01*h2_dc_14 + -1.4473353326320648e-01*h2_dc_15 + -8.716844767332077e-02*h2_dc_16 + 4.540345631539822e-03*h2_dc_17 + 3.994537144899368e-02*h2_dc_18 + 1.3187555968761444e-01*h2_dc_19 + -1.571858674287796e-01*h2_dc_20 + -1.2107822299003601e-01*h2_dc_21 + -4.797682911157608e-02*h2_dc_22 + 1.9206702709197998e-01*h2_dc_23 + 1.3299013674259186e-01*h2_dc_24 + -2.7817302942276e-01*h2_dc_25 + 1.9746968150138855e-01*h2_dc_26 + -2.8086481615900993e-02*h2_dc_27 + 3.780938684940338e-01*h2_dc_28 + -3.243055045604706e-01*h2_dc_29 + 8.855357766151428e-02*h2_dc_30 + 3.16692054271698e-01*h2_dc_31 + -1.1200936883687973e-01;
    gi = 0.5*(h3_dc_7)*(1 + tanh(0.7978845608*((h3_dc_7) + 0.044715*(h3_dc_7)*(h3_dc_7)*(h3_dc_7)))); h3_dc_7 = gi;
    y0_dc = 2.3851078748703003e-01*h3_dc_0 + 6.498607248067856e-02*h3_dc_1 + -4.09785658121109e-01*h3_dc_2 + -3.292425274848938e-01*h3_dc_3 + -8.663896322250366e-01*h3_dc_4 + -7.76364803314209e-01*h3_dc_5 + 4.327695369720459e-01*h3_dc_6 + -5.055426359176636e-01*h3_dc_7 + -1.0227987542748451e-02;
    id_log = y0_dc * 2.8072023540977344e+00 + -1.1537687366813808e+01;
    id_raw = exp(id_log) - 1.0e-10;
    if (id_raw < 1e-30) id_raw = 1e-30;
    gate_exp = exp((-V(g,s) - VTH_EFF) / (OFF_GAIN * VTSCALE));
    if (gate_exp > 1.0) gate_exp = 1.0;
    Id_si = -id_raw * gate_exp;
    I(d,s) <+ Id_si;
    // PMOS: d/s (p+) -> body (nwell, b=VDD); forward when V(d,b)>0, V(s,b)>0. Current d/s->b pulls node back.
    if (enable_junction > 0.5) begin
      Vdb = V(d,b);
      Vsb = V(s,b);
      if (Vdb > 0) I(d,b) <+ Isj * (limexp(Vdb / (Nj * 0.02585)) - 1.0);
      if (Vsb > 0) I(s,b) <+ Isj * (limexp(Vsb / (Nj * 0.02585)) - 1.0);
    end
    xs_ac_0 = (x0 - 1.800065588877501e-02) / 2.830146136622999e-03;
    xs_ac_1 = (x1 - 2.499644711669855e+00) / 1.1175449337313141e+00;
    xs_ac_2 = (x2 - 1.5006777737204816e-09) / 3.161583218554737e-10;
    xs_ac_3 = (x3 - -4.7698688216891266e-01) / 3.133303624115445e-01;
    xs_ac_4 = (x4 - -4.996768247986726e-01) / 3.029228071389752e-01;
    xs_ac_5 = (x5 - 0.0) / 1.0;
    xs_ac_6 = (x6 - 0.0) / 1.0;
    h1_ac_0 = 3.983299806714058e-02*xs_ac_0 + 5.767822861671448e-01*xs_ac_1 + -7.296542823314667e-02*xs_ac_2 + 8.842068910598755e-02*xs_ac_3 + -1.6436375677585602e-01*xs_ac_4 + -5.710088014602661e-01*xs_ac_5 + 1.898326724767685e-01*xs_ac_6 + 9.742370992898941e-02;
    gi = 0.5*(h1_ac_0)*(1 + tanh(0.7978845608*((h1_ac_0) + 0.044715*(h1_ac_0)*(h1_ac_0)*(h1_ac_0)))); h1_ac_0 = gi;
    h1_ac_1 = 1.2147146463394165e-01*xs_ac_0 + -1.1909603327512741e-01*xs_ac_1 + 8.621492236852646e-02*xs_ac_2 + 3.1528130173683167e-01*xs_ac_3 + 6.110666990280151e-01*xs_ac_4 + 5.366840213537216e-02*xs_ac_5 + 3.298530355095863e-02*xs_ac_6 + -1.072884351015091e-01;
    gi = 0.5*(h1_ac_1)*(1 + tanh(0.7978845608*((h1_ac_1) + 0.044715*(h1_ac_1)*(h1_ac_1)*(h1_ac_1)))); h1_ac_1 = gi;
    h1_ac_2 = -6.08440600335598e-02*xs_ac_0 + -8.285531401634216e-02*xs_ac_1 + -9.429237246513367e-02*xs_ac_2 + -1.2283028336241841e-03*xs_ac_3 + -5.385475754737854e-01*xs_ac_4 + -6.493971943855286e-01*xs_ac_5 + -7.886022925376892e-01*xs_ac_6 + 2.547956705093384e-01;
    gi = 0.5*(h1_ac_2)*(1 + tanh(0.7978845608*((h1_ac_2) + 0.044715*(h1_ac_2)*(h1_ac_2)*(h1_ac_2)))); h1_ac_2 = gi;
    h1_ac_3 = 1.099797710776329e-01*xs_ac_0 + -3.7333881855010986e-01*xs_ac_1 + 5.696960911154747e-02*xs_ac_2 + 1.539304256439209e-01*xs_ac_3 + 5.587220788002014e-01*xs_ac_4 + 4.2017409205436707e-01*xs_ac_5 + -6.593071818351746e-01*xs_ac_6 + 9.700039774179459e-02;
    gi = 0.5*(h1_ac_3)*(1 + tanh(0.7978845608*((h1_ac_3) + 0.044715*(h1_ac_3)*(h1_ac_3)*(h1_ac_3)))); h1_ac_3 = gi;
    h1_ac_4 = 1.1625239998102188e-01*xs_ac_0 + -8.593656420707703e-01*xs_ac_1 + 8.06351825594902e-02*xs_ac_2 + 9.068847894668579e-01*xs_ac_3 + 3.985064625740051e-01*xs_ac_4 + -2.145812213420868e-01*xs_ac_5 + -6.178568005561829e-01*xs_ac_6 + 2.7257370948791504e-01;
    gi = 0.5*(h1_ac_4)*(1 + tanh(0.7978845608*((h1_ac_4) + 0.044715*(h1_ac_4)*(h1_ac_4)*(h1_ac_4)))); h1_ac_4 = gi;
    h1_ac_5 = -1.696147955954075e-02*xs_ac_0 + 4.0854039788246155e-01*xs_ac_1 + -3.2324470579624176e-02*xs_ac_2 + -2.1008795499801636e-01*xs_ac_3 + -3.95086407661438e-01*xs_ac_4 + 3.535589575767517e-01*xs_ac_5 + 1.9706089794635773e-01*xs_ac_6 + 6.776846945285797e-02;
    gi = 0.5*(h1_ac_5)*(1 + tanh(0.7978845608*((h1_ac_5) + 0.044715*(h1_ac_5)*(h1_ac_5)*(h1_ac_5)))); h1_ac_5 = gi;
    h1_ac_6 = 8.961938321590424e-02*xs_ac_0 + 9.050940722227097e-02*xs_ac_1 + -1.1950885504484177e-01*xs_ac_2 + -2.152835875749588e-01*xs_ac_3 + -5.809715986251831e-01*xs_ac_4 + -2.230389267206192e-01*xs_ac_5 + 3.364621102809906e-01*xs_ac_6 + 1.914728879928589e-01;
    gi = 0.5*(h1_ac_6)*(1 + tanh(0.7978845608*((h1_ac_6) + 0.044715*(h1_ac_6)*(h1_ac_6)*(h1_ac_6)))); h1_ac_6 = gi;
    h1_ac_7 = -1.581188440322876e-01*xs_ac_0 + -1.4757151901721954e-01*xs_ac_1 + -1.1744914948940277e-01*xs_ac_2 + -2.6418325304985046e-01*xs_ac_3 + -4.2866748571395874e-01*xs_ac_4 + -3.152281641960144e-01*xs_ac_5 + -4.6909254789352417e-01*xs_ac_6 + -6.992544233798981e-02;
    gi = 0.5*(h1_ac_7)*(1 + tanh(0.7978845608*((h1_ac_7) + 0.044715*(h1_ac_7)*(h1_ac_7)*(h1_ac_7)))); h1_ac_7 = gi;
    h1_ac_8 = 1.2096233665943146e-01*xs_ac_0 + 2.95571893453598e-01*xs_ac_1 + 8.961746096611023e-02*xs_ac_2 + 7.355296611785889e-02*xs_ac_3 + 4.438328742980957e-01*xs_ac_4 + -1.6498446464538574e-01*xs_ac_5 + 6.286343932151794e-01*xs_ac_6 + -1.1159789748489857e-02;
    gi = 0.5*(h1_ac_8)*(1 + tanh(0.7978845608*((h1_ac_8) + 0.044715*(h1_ac_8)*(h1_ac_8)*(h1_ac_8)))); h1_ac_8 = gi;
    h1_ac_9 = -7.904929667711258e-02*xs_ac_0 + 7.555728554725647e-01*xs_ac_1 + -7.334183156490326e-02*xs_ac_2 + -7.232781648635864e-01*xs_ac_3 + -8.718962222337723e-02*xs_ac_4 + -3.813173174858093e-01*xs_ac_5 + 1.7273107171058655e-01*xs_ac_6 + 2.148730605840683e-01;
    gi = 0.5*(h1_ac_9)*(1 + tanh(0.7978845608*((h1_ac_9) + 0.044715*(h1_ac_9)*(h1_ac_9)*(h1_ac_9)))); h1_ac_9 = gi;
    h1_ac_10 = 6.674933433532715e-02*xs_ac_0 + 3.958819508552551e-01*xs_ac_1 + 4.54106405377388e-02*xs_ac_2 + -2.849646806716919e-01*xs_ac_3 + -4.024583101272583e-02*xs_ac_4 + -1.17552749812603e-01*xs_ac_5 + -1.864599883556366e-01*xs_ac_6 + 3.461534380912781e-01;
    gi = 0.5*(h1_ac_10)*(1 + tanh(0.7978845608*((h1_ac_10) + 0.044715*(h1_ac_10)*(h1_ac_10)*(h1_ac_10)))); h1_ac_10 = gi;
    h1_ac_11 = 1.8420733511447906e-02*xs_ac_0 + -1.2342625111341476e-01*xs_ac_1 + 5.432898923754692e-02*xs_ac_2 + -4.7288650274276733e-01*xs_ac_3 + 5.109429359436035e-01*xs_ac_4 + 4.3008577823638916e-01*xs_ac_5 + 5.361589789390564e-01*xs_ac_6 + 3.4913577139377594e-02;
    gi = 0.5*(h1_ac_11)*(1 + tanh(0.7978845608*((h1_ac_11) + 0.044715*(h1_ac_11)*(h1_ac_11)*(h1_ac_11)))); h1_ac_11 = gi;
    h1_ac_12 = 4.472160711884499e-03*xs_ac_0 + -5.559864640235901e-01*xs_ac_1 + 2.415839210152626e-02*xs_ac_2 + -2.3327314853668213e-01*xs_ac_3 + -8.725214749574661e-02*xs_ac_4 + 8.654520511627197e-01*xs_ac_5 + 7.674008011817932e-01*xs_ac_6 + 3.747256100177765e-01;
    gi = 0.5*(h1_ac_12)*(1 + tanh(0.7978845608*((h1_ac_12) + 0.044715*(h1_ac_12)*(h1_ac_12)*(h1_ac_12)))); h1_ac_12 = gi;
    h1_ac_13 = 4.0586055256426334e-03*xs_ac_0 + 5.436616539955139e-01*xs_ac_1 + -1.883307844400406e-02*xs_ac_2 + 6.440670788288116e-02*xs_ac_3 + 3.835070729255676e-01*xs_ac_4 + -4.861284792423248e-02*xs_ac_5 + -2.9445546865463257e-01*xs_ac_6 + -1.0747882723808289e-01;
    gi = 0.5*(h1_ac_13)*(1 + tanh(0.7978845608*((h1_ac_13) + 0.044715*(h1_ac_13)*(h1_ac_13)*(h1_ac_13)))); h1_ac_13 = gi;
    h1_ac_14 = -2.9240094125270844e-02*xs_ac_0 + -9.972059726715088e-02*xs_ac_1 + 1.108418870717287e-02*xs_ac_2 + -1.090312123298645e+00*xs_ac_3 + 9.50445830821991e-01*xs_ac_4 + 4.4176486134529114e-01*xs_ac_5 + -1.500856578350067e-01*xs_ac_6 + -4.511129856109619e-01;
    gi = 0.5*(h1_ac_14)*(1 + tanh(0.7978845608*((h1_ac_14) + 0.044715*(h1_ac_14)*(h1_ac_14)*(h1_ac_14)))); h1_ac_14 = gi;
    h1_ac_15 = 3.616441413760185e-02*xs_ac_0 + 1.7559309303760529e-01*xs_ac_1 + -3.5069435834884644e-02*xs_ac_2 + 6.741911172866821e-01*xs_ac_3 + -5.389110445976257e-01*xs_ac_4 + -4.316648840904236e-02*xs_ac_5 + -1.73716202378273e-01*xs_ac_6 + 2.464836984872818e-01;
    gi = 0.5*(h1_ac_15)*(1 + tanh(0.7978845608*((h1_ac_15) + 0.044715*(h1_ac_15)*(h1_ac_15)*(h1_ac_15)))); h1_ac_15 = gi;
    h2_ac_0 = -2.361428588628769e-01*h1_ac_0 + 3.786666691303253e-01*h1_ac_1 + -3.194010257720947e-02*h1_ac_2 + 9.51070562005043e-02*h1_ac_3 + -3.5171058773994446e-01*h1_ac_4 + 1.1925719678401947e-01*h1_ac_5 + 1.547740250825882e-01*h1_ac_6 + 2.7540040016174316e-01*h1_ac_7 + -3.3575180172920227e-01*h1_ac_8 + -4.5632109977304935e-03*h1_ac_9 + -2.17203751206398e-01*h1_ac_10 + 2.46084526181221e-01*h1_ac_11 + 4.794081449508667e-01*h1_ac_12 + 2.9416751861572266e-01*h1_ac_13 + 9.723791480064392e-02*h1_ac_14 + 2.903197109699249e-01*h1_ac_15 + 5.980573128908873e-03;
    gi = 0.5*(h2_ac_0)*(1 + tanh(0.7978845608*((h2_ac_0) + 0.044715*(h2_ac_0)*(h2_ac_0)*(h2_ac_0)))); h2_ac_0 = gi;
    h2_ac_1 = 7.811153680086136e-02*h1_ac_0 + -1.7439961433410645e-01*h1_ac_1 + 3.0317971110343933e-01*h1_ac_2 + 1.0689624585211277e-02*h1_ac_3 + -6.804216504096985e-01*h1_ac_4 + 2.0162159204483032e-01*h1_ac_5 + 2.1612343192100525e-01*h1_ac_6 + -4.438624083995819e-01*h1_ac_7 + -1.6669419407844543e-01*h1_ac_8 + -9.084609150886536e-01*h1_ac_9 + -4.731150269508362e-01*h1_ac_10 + 1.5661492943763733e-04*h1_ac_11 + 7.54841148853302e-01*h1_ac_12 + -5.729098320007324e-01*h1_ac_13 + -2.2206708788871765e-01*h1_ac_14 + -2.0062920451164246e-01*h1_ac_15 + -2.22405344247818e-01;
    gi = 0.5*(h2_ac_1)*(1 + tanh(0.7978845608*((h2_ac_1) + 0.044715*(h2_ac_1)*(h2_ac_1)*(h2_ac_1)))); h2_ac_1 = gi;
    h2_ac_2 = 1.311672329902649e-01*h1_ac_0 + -1.662132516503334e-02*h1_ac_1 + -1.592731475830078e-01*h1_ac_2 + -7.760006189346313e-02*h1_ac_3 + 6.665346026420593e-01*h1_ac_4 + -5.3570106625556946e-02*h1_ac_5 + -3.4597522020339966e-01*h1_ac_6 + 2.8550010919570923e-01*h1_ac_7 + -8.099380135536194e-01*h1_ac_8 + 4.999392107129097e-02*h1_ac_9 + 3.209129273891449e-01*h1_ac_10 + 4.58609014749527e-02*h1_ac_11 + 2.219516634941101e-01*h1_ac_12 + -4.22903448343277e-02*h1_ac_13 + -6.871123611927032e-02*h1_ac_14 + 3.8879773020744324e-01*h1_ac_15 + 1.0254928469657898e-01;
    gi = 0.5*(h2_ac_2)*(1 + tanh(0.7978845608*((h2_ac_2) + 0.044715*(h2_ac_2)*(h2_ac_2)*(h2_ac_2)))); h2_ac_2 = gi;
    h2_ac_3 = -4.6192294359207153e-01*h1_ac_0 + -1.089148223400116e-01*h1_ac_1 + 3.6573904752731323e-01*h1_ac_2 + 2.8535589575767517e-01*h1_ac_3 + 3.5782578587532043e-01*h1_ac_4 + -3.801838755607605e-01*h1_ac_5 + 4.3980172276496887e-01*h1_ac_6 + -1.1313176155090332e-01*h1_ac_7 + 1.7866217531263828e-03*h1_ac_8 + 3.688603341579437e-01*h1_ac_9 + -4.711674451828003e-01*h1_ac_10 + -2.695366181433201e-02*h1_ac_11 + -1.9242140650749207e-01*h1_ac_12 + 5.063695907592773e-01*h1_ac_13 + 2.0545382797718048e-01*h1_ac_14 + -5.468355864286423e-02*h1_ac_15 + 9.304521232843399e-02;
    gi = 0.5*(h2_ac_3)*(1 + tanh(0.7978845608*((h2_ac_3) + 0.044715*(h2_ac_3)*(h2_ac_3)*(h2_ac_3)))); h2_ac_3 = gi;
    h2_ac_4 = -4.2300575971603394e-01*h1_ac_0 + 1.351335495710373e-01*h1_ac_1 + -2.4356042966246605e-02*h1_ac_2 + 1.6325224936008453e-01*h1_ac_3 + 4.252814054489136e-01*h1_ac_4 + -3.8725951313972473e-01*h1_ac_5 + 4.723016545176506e-02*h1_ac_6 + 2.584507465362549e-01*h1_ac_7 + -9.721145778894424e-02*h1_ac_8 + 2.651832439005375e-02*h1_ac_9 + 3.6722204089164734e-01*h1_ac_10 + -3.0853718519210815e-01*h1_ac_11 + 4.7602522373199463e-01*h1_ac_12 + 3.0894753336906433e-01*h1_ac_13 + -2.0987580716609955e-01*h1_ac_14 + 4.382992088794708e-01*h1_ac_15 + 8.206165581941605e-02;
    gi = 0.5*(h2_ac_4)*(1 + tanh(0.7978845608*((h2_ac_4) + 0.044715*(h2_ac_4)*(h2_ac_4)*(h2_ac_4)))); h2_ac_4 = gi;
    h2_ac_5 = 2.755029797554016e-01*h1_ac_0 + 3.1278449296951294e-01*h1_ac_1 + -4.7154778242111206e-01*h1_ac_2 + 4.6141692996025085e-01*h1_ac_3 + -2.5341784954071045e-01*h1_ac_4 + 7.07780122756958e-02*h1_ac_5 + -1.1030023917555809e-02*h1_ac_6 + 1.090075746178627e-01*h1_ac_7 + -4.9208980798721313e-01*h1_ac_8 + 2.3426534235477448e-01*h1_ac_9 + -5.00710129737854e-01*h1_ac_10 + 3.9460235834121704e-01*h1_ac_11 + 1.1488856375217438e-01*h1_ac_12 + -8.268281072378159e-02*h1_ac_13 + 1.4875832200050354e-01*h1_ac_14 + 2.6814785599708557e-01*h1_ac_15 + -1.1769222095608711e-02;
    gi = 0.5*(h2_ac_5)*(1 + tanh(0.7978845608*((h2_ac_5) + 0.044715*(h2_ac_5)*(h2_ac_5)*(h2_ac_5)))); h2_ac_5 = gi;
    h2_ac_6 = 2.3426231741905212e-01*h1_ac_0 + 4.233616292476654e-01*h1_ac_1 + 1.9455337524414062e-01*h1_ac_2 + 5.512199550867081e-02*h1_ac_3 + 1.6433195769786835e-01*h1_ac_4 + -7.017711400985718e-01*h1_ac_5 + 4.45321261882782e-01*h1_ac_6 + 3.64161878824234e-02*h1_ac_7 + 1.5196295082569122e-01*h1_ac_8 + 1.3631172478199005e-01*h1_ac_9 + -7.015824317932129e-02*h1_ac_10 + 3.733804225921631e-01*h1_ac_11 + 2.790132351219654e-02*h1_ac_12 + 1.5384286642074585e-01*h1_ac_13 + 3.0556806921958923e-01*h1_ac_14 + -6.559568047523499e-01*h1_ac_15 + 7.9689621925354e-02;
    gi = 0.5*(h2_ac_6)*(1 + tanh(0.7978845608*((h2_ac_6) + 0.044715*(h2_ac_6)*(h2_ac_6)*(h2_ac_6)))); h2_ac_6 = gi;
    h2_ac_7 = 3.6467233300209045e-01*h1_ac_0 + -5.842927694320679e-01*h1_ac_1 + -2.6233944296836853e-01*h1_ac_2 + 2.521568238735199e-01*h1_ac_3 + 3.016270697116852e-01*h1_ac_4 + -4.9222734570503235e-01*h1_ac_5 + 1.2201515026390553e-02*h1_ac_6 + 1.2907551229000092e-01*h1_ac_7 + 4.9962231516838074e-01*h1_ac_8 + -2.951231002807617e-01*h1_ac_9 + -2.519310414791107e-01*h1_ac_10 + -4.6079516410827637e-01*h1_ac_11 + -5.359964370727539e-01*h1_ac_12 + -1.8892306834459305e-02*h1_ac_13 + -3.3499738574028015e-01*h1_ac_14 + 4.788195490837097e-01*h1_ac_15 + 2.3067109286785126e-01;
    gi = 0.5*(h2_ac_7)*(1 + tanh(0.7978845608*((h2_ac_7) + 0.044715*(h2_ac_7)*(h2_ac_7)*(h2_ac_7)))); h2_ac_7 = gi;
    h2_ac_8 = -2.5377973914146423e-01*h1_ac_0 + 3.6061590909957886e-01*h1_ac_1 + -4.11607027053833e-01*h1_ac_2 + 7.36241564154625e-02*h1_ac_3 + -4.48203943669796e-02*h1_ac_4 + 3.741277754306793e-01*h1_ac_5 + 3.674693703651428e-01*h1_ac_6 + 4.243549704551697e-01*h1_ac_7 + -2.6195481419563293e-01*h1_ac_8 + 3.576219379901886e-01*h1_ac_9 + -1.556837409734726e-01*h1_ac_10 + 2.19362273812294e-01*h1_ac_11 + -1.8334732949733734e-01*h1_ac_12 + -5.108135938644409e-02*h1_ac_13 + -5.334874987602234e-01*h1_ac_14 + -4.9677810072898865e-01*h1_ac_15 + 4.3661605566740036e-02;
    gi = 0.5*(h2_ac_8)*(1 + tanh(0.7978845608*((h2_ac_8) + 0.044715*(h2_ac_8)*(h2_ac_8)*(h2_ac_8)))); h2_ac_8 = gi;
    h2_ac_9 = 1.0230947285890579e-01*h1_ac_0 + 7.270889729261398e-02*h1_ac_1 + -2.731536030769348e-01*h1_ac_2 + 6.458922624588013e-01*h1_ac_3 + -3.432065546512604e-01*h1_ac_4 + 3.080260753631592e-01*h1_ac_5 + -2.2258083522319794e-01*h1_ac_6 + 2.4604789912700653e-01*h1_ac_7 + 2.0709452033042908e-01*h1_ac_8 + 4.006159007549286e-01*h1_ac_9 + 1.3687816262245178e-01*h1_ac_10 + -2.3397527635097504e-01*h1_ac_11 + 3.9468541741371155e-01*h1_ac_12 + 1.708158701658249e-01*h1_ac_13 + -4.2039763927459717e-01*h1_ac_14 + 1.5257515013217926e-01*h1_ac_15 + -6.1944380402565e-02;
    gi = 0.5*(h2_ac_9)*(1 + tanh(0.7978845608*((h2_ac_9) + 0.044715*(h2_ac_9)*(h2_ac_9)*(h2_ac_9)))); h2_ac_9 = gi;
    h2_ac_10 = 1.6220872104167938e-01*h1_ac_0 + -2.430730164051056e-01*h1_ac_1 + -3.086482360959053e-02*h1_ac_2 + 7.457152754068375e-02*h1_ac_3 + 6.99888588860631e-03*h1_ac_4 + -2.1281030774116516e-01*h1_ac_5 + 8.909911662340164e-02*h1_ac_6 + -1.7685993015766144e-01*h1_ac_7 + 2.648203372955322e-01*h1_ac_8 + 4.8192211985588074e-01*h1_ac_9 + -2.512834370136261e-01*h1_ac_10 + -4.8114654421806335e-01*h1_ac_11 + 4.236103966832161e-02*h1_ac_12 + -1.2140840291976929e-01*h1_ac_13 + 1.18038110435009e-01*h1_ac_14 + -8.423186540603638e-01*h1_ac_15 + -1.2036016583442688e-01;
    gi = 0.5*(h2_ac_10)*(1 + tanh(0.7978845608*((h2_ac_10) + 0.044715*(h2_ac_10)*(h2_ac_10)*(h2_ac_10)))); h2_ac_10 = gi;
    h2_ac_11 = 1.7027029395103455e-01*h1_ac_0 + -3.773649036884308e-01*h1_ac_1 + 4.982217848300934e-01*h1_ac_2 + 3.350217938423157e-01*h1_ac_3 + 1.2082156538963318e-01*h1_ac_4 + -1.4131541550159454e-01*h1_ac_5 + 1.223786398768425e-01*h1_ac_6 + 2.0471379160881042e-01*h1_ac_7 + -3.8046830892562866e-01*h1_ac_8 + -8.59413892030716e-02*h1_ac_9 + 6.515591740608215e-01*h1_ac_10 + -2.475300282239914e-01*h1_ac_11 + -9.395972639322281e-02*h1_ac_12 + -1.6680477559566498e-01*h1_ac_13 + 8.922713249921799e-02*h1_ac_14 + -2.4347232282161713e-01*h1_ac_15 + 3.408803343772888e-01;
    gi = 0.5*(h2_ac_11)*(1 + tanh(0.7978845608*((h2_ac_11) + 0.044715*(h2_ac_11)*(h2_ac_11)*(h2_ac_11)))); h2_ac_11 = gi;
    h2_ac_12 = -4.362354278564453e-01*h1_ac_0 + -1.2078090012073517e-01*h1_ac_1 + 1.9758912920951843e-01*h1_ac_2 + 2.6598241925239563e-01*h1_ac_3 + 4.525529742240906e-01*h1_ac_4 + -2.4406346678733826e-01*h1_ac_5 + 7.29629322886467e-02*h1_ac_6 + -2.9172074794769287e-01*h1_ac_7 + 2.6514267921447754e-01*h1_ac_8 + 2.953183650970459e-01*h1_ac_9 + 2.7982664108276367e-01*h1_ac_10 + -1.735244244337082e-01*h1_ac_11 + 5.869823098182678e-01*h1_ac_12 + -4.6956175565719604e-01*h1_ac_13 + -2.1227262914180756e-01*h1_ac_14 + 1.8990853428840637e-01*h1_ac_15 + -1.3791082799434662e-01;
    gi = 0.5*(h2_ac_12)*(1 + tanh(0.7978845608*((h2_ac_12) + 0.044715*(h2_ac_12)*(h2_ac_12)*(h2_ac_12)))); h2_ac_12 = gi;
    h2_ac_13 = -5.151470899581909e-01*h1_ac_0 + -1.2725988030433655e-01*h1_ac_1 + -6.634883284568787e-01*h1_ac_2 + 1.7592880129814148e-01*h1_ac_3 + 9.436345100402832e-02*h1_ac_4 + 1.0700076073408127e-01*h1_ac_5 + 2.944319322705269e-02*h1_ac_6 + 5.02470850944519e-01*h1_ac_7 + -5.496997386217117e-03*h1_ac_8 + 3.9224565029144287e-01*h1_ac_9 + 3.1865307688713074e-01*h1_ac_10 + -4.992598295211792e-01*h1_ac_11 + -2.7851569652557373e-01*h1_ac_12 + 4.904525578022003e-01*h1_ac_13 + 5.40004551410675e-01*h1_ac_14 + -3.62972617149353e-01*h1_ac_15 + -4.024651646614075e-02;
    gi = 0.5*(h2_ac_13)*(1 + tanh(0.7978845608*((h2_ac_13) + 0.044715*(h2_ac_13)*(h2_ac_13)*(h2_ac_13)))); h2_ac_13 = gi;
    h2_ac_14 = 1.730010062456131e-01*h1_ac_0 + -2.210027277469635e-01*h1_ac_1 + 5.594732761383057e-01*h1_ac_2 + 2.8011178970336914e-01*h1_ac_3 + 3.9536598324775696e-01*h1_ac_4 + 2.3436707258224487e-01*h1_ac_5 + -1.5590576827526093e-01*h1_ac_6 + 3.900560736656189e-01*h1_ac_7 + -1.324048489332199e-01*h1_ac_8 + -1.0214298963546753e-01*h1_ac_9 + 7.413965184241533e-03*h1_ac_10 + -4.240540862083435e-01*h1_ac_11 + -4.4741159677505493e-01*h1_ac_12 + 5.342968702316284e-01*h1_ac_13 + -2.63986773788929e-02*h1_ac_14 + -2.2651445865631104e-01*h1_ac_15 + -3.0939367413520813e-01;
    gi = 0.5*(h2_ac_14)*(1 + tanh(0.7978845608*((h2_ac_14) + 0.044715*(h2_ac_14)*(h2_ac_14)*(h2_ac_14)))); h2_ac_14 = gi;
    h2_ac_15 = 2.915843427181244e-01*h1_ac_0 + 3.008106052875519e-01*h1_ac_1 + -4.21373188495636e-01*h1_ac_2 + 9.312837570905685e-02*h1_ac_3 + -4.650867283344269e-01*h1_ac_4 + 1.7684686183929443e-01*h1_ac_5 + -1.1460224539041519e-01*h1_ac_6 + -1.8430915474891663e-01*h1_ac_7 + 1.55864879488945e-01*h1_ac_8 + 3.875869810581207e-01*h1_ac_9 + 5.025184154510498e-01*h1_ac_10 + -3.2425668090581894e-02*h1_ac_11 + 2.2317396104335785e-01*h1_ac_12 + -2.3555025458335876e-01*h1_ac_13 + 1.3350310921669006e-01*h1_ac_14 + 3.889017403125763e-01*h1_ac_15 + -7.752053439617157e-03;
    gi = 0.5*(h2_ac_15)*(1 + tanh(0.7978845608*((h2_ac_15) + 0.044715*(h2_ac_15)*(h2_ac_15)*(h2_ac_15)))); h2_ac_15 = gi;
    h2_ac_16 = -2.5298503041267395e-01*h1_ac_0 + -3.8435620069503784e-01*h1_ac_1 + 3.422534167766571e-01*h1_ac_2 + 2.704724669456482e-01*h1_ac_3 + -4.2053985595703125e-01*h1_ac_4 + -5.73692798614502e-01*h1_ac_5 + 2.375761866569519e-01*h1_ac_6 + 3.7319526076316833e-02*h1_ac_7 + -1.747761070728302e-01*h1_ac_8 + -9.732162207365036e-02*h1_ac_9 + 5.025783777236938e-01*h1_ac_10 + -1.9126948714256287e-01*h1_ac_11 + 3.6320197582244873e-01*h1_ac_12 + 3.323790431022644e-01*h1_ac_13 + -5.323443561792374e-02*h1_ac_14 + 2.615342140197754e-01*h1_ac_15 + 6.583361029624939e-01;
    gi = 0.5*(h2_ac_16)*(1 + tanh(0.7978845608*((h2_ac_16) + 0.044715*(h2_ac_16)*(h2_ac_16)*(h2_ac_16)))); h2_ac_16 = gi;
    h2_ac_17 = 1.2930060923099518e-01*h1_ac_0 + -9.00576040148735e-02*h1_ac_1 + 3.151346445083618e-01*h1_ac_2 + -2.398775964975357e-01*h1_ac_3 + 4.21735942363739e-01*h1_ac_4 + -2.3790550231933594e-01*h1_ac_5 + -2.1444997191429138e-01*h1_ac_6 + 4.356682598590851e-01*h1_ac_7 + 8.573254197835922e-02*h1_ac_8 + -6.427685022354126e-01*h1_ac_9 + 3.312622904777527e-01*h1_ac_10 + -5.32126247882843e-01*h1_ac_11 + 5.503762364387512e-01*h1_ac_12 + -1.978454887866974e-01*h1_ac_13 + 3.9408957958221436e-01*h1_ac_14 + 6.860623508691788e-02*h1_ac_15 + 5.840134248137474e-02;
    gi = 0.5*(h2_ac_17)*(1 + tanh(0.7978845608*((h2_ac_17) + 0.044715*(h2_ac_17)*(h2_ac_17)*(h2_ac_17)))); h2_ac_17 = gi;
    h2_ac_18 = 3.0779004096984863e-01*h1_ac_0 + 3.933073878288269e-01*h1_ac_1 + -8.773808181285858e-02*h1_ac_2 + -2.4174633622169495e-01*h1_ac_3 + 2.246035933494568e-01*h1_ac_4 + 5.722551345825195e-01*h1_ac_5 + 1.5028852224349976e-01*h1_ac_6 + 3.0975544452667236e-01*h1_ac_7 + 1.6021285951137543e-01*h1_ac_8 + -4.050070345401764e-01*h1_ac_9 + -2.2874021530151367e-01*h1_ac_10 + -7.37985223531723e-02*h1_ac_11 + -2.539321081712842e-03*h1_ac_12 + 5.758374929428101e-01*h1_ac_13 + -6.595271825790405e-01*h1_ac_14 + 4.6729449182748795e-02*h1_ac_15 + -7.497572898864746e-02;
    gi = 0.5*(h2_ac_18)*(1 + tanh(0.7978845608*((h2_ac_18) + 0.044715*(h2_ac_18)*(h2_ac_18)*(h2_ac_18)))); h2_ac_18 = gi;
    h2_ac_19 = -3.2985810190439224e-02*h1_ac_0 + 4.8598628491163254e-02*h1_ac_1 + 5.088104009628296e-01*h1_ac_2 + 1.4288575947284698e-01*h1_ac_3 + -1.5337850153446198e-01*h1_ac_4 + -5.827493071556091e-01*h1_ac_5 + -4.1605597734451294e-01*h1_ac_6 + -6.281962394714355e-01*h1_ac_7 + 3.4922486543655396e-01*h1_ac_8 + -3.480169475078583e-01*h1_ac_9 + 8.475369960069656e-02*h1_ac_10 + 1.9918639957904816e-01*h1_ac_11 + 2.115923911333084e-01*h1_ac_12 + -3.9254888892173767e-01*h1_ac_13 + -2.8442373871803284e-01*h1_ac_14 + 9.123806655406952e-02*h1_ac_15 + 6.1914749443531036e-02;
    gi = 0.5*(h2_ac_19)*(1 + tanh(0.7978845608*((h2_ac_19) + 0.044715*(h2_ac_19)*(h2_ac_19)*(h2_ac_19)))); h2_ac_19 = gi;
    h2_ac_20 = 2.818014919757843e-01*h1_ac_0 + -2.6969292759895325e-01*h1_ac_1 + -1.1303642392158508e-01*h1_ac_2 + 2.792432904243469e-01*h1_ac_3 + 1.6287043690681458e-01*h1_ac_4 + 1.3074487447738647e-01*h1_ac_5 + -1.8206925690174103e-01*h1_ac_6 + 2.3134228587150574e-01*h1_ac_7 + -1.176371704787016e-02*h1_ac_8 + -2.320771962404251e-01*h1_ac_9 + 2.500755190849304e-01*h1_ac_10 + -1.412821114063263e-01*h1_ac_11 + 2.0198239386081696e-01*h1_ac_12 + 8.412020280957222e-03*h1_ac_13 + -6.922451853752136e-01*h1_ac_14 + -1.9789406657218933e-01*h1_ac_15 + 1.7344634234905243e-01;
    gi = 0.5*(h2_ac_20)*(1 + tanh(0.7978845608*((h2_ac_20) + 0.044715*(h2_ac_20)*(h2_ac_20)*(h2_ac_20)))); h2_ac_20 = gi;
    h2_ac_21 = 4.05364990234375e-01*h1_ac_0 + -2.1566933020949364e-02*h1_ac_1 + 1.4724114537239075e-01*h1_ac_2 + 1.2678104639053345e-01*h1_ac_3 + -1.3128991238772869e-02*h1_ac_4 + 4.3052932620048523e-01*h1_ac_5 + -1.1700901389122009e-01*h1_ac_6 + 1.3005442917346954e-01*h1_ac_7 + 2.1944843232631683e-01*h1_ac_8 + -3.923541307449341e-01*h1_ac_9 + -9.675149619579315e-02*h1_ac_10 + -1.580832302570343e-01*h1_ac_11 + -8.533599972724915e-02*h1_ac_12 + 1.3566115498542786e-01*h1_ac_13 + -1.1847649812698364e+00*h1_ac_14 + -2.8475329279899597e-01*h1_ac_15 + 1.8159158527851105e-01;
    gi = 0.5*(h2_ac_21)*(1 + tanh(0.7978845608*((h2_ac_21) + 0.044715*(h2_ac_21)*(h2_ac_21)*(h2_ac_21)))); h2_ac_21 = gi;
    h2_ac_22 = -5.478391423821449e-02*h1_ac_0 + 6.073645949363708e-01*h1_ac_1 + 1.6354528069496155e-01*h1_ac_2 + -4.283553957939148e-01*h1_ac_3 + 1.0079791396856308e-01*h1_ac_4 + 8.178818970918655e-02*h1_ac_5 + 3.670696020126343e-01*h1_ac_6 + 1.1043307185173035e-01*h1_ac_7 + -1.955147534608841e-01*h1_ac_8 + 4.01401549577713e-01*h1_ac_9 + -3.277624398469925e-02*h1_ac_10 + -1.5224546194076538e-01*h1_ac_11 + -6.987062841653824e-02*h1_ac_12 + 4.911150634288788e-01*h1_ac_13 + 2.1610645949840546e-01*h1_ac_14 + -4.7456344962120056e-01*h1_ac_15 + -4.071991890668869e-02;
    gi = 0.5*(h2_ac_22)*(1 + tanh(0.7978845608*((h2_ac_22) + 0.044715*(h2_ac_22)*(h2_ac_22)*(h2_ac_22)))); h2_ac_22 = gi;
    h2_ac_23 = 4.4080158695578575e-03*h1_ac_0 + 5.349730253219604e-01*h1_ac_1 + -2.4423809349536896e-01*h1_ac_2 + 4.822314530611038e-02*h1_ac_3 + -4.207443594932556e-01*h1_ac_4 + -7.400007545948029e-02*h1_ac_5 + -1.626637727022171e-01*h1_ac_6 + -9.862786531448364e-02*h1_ac_7 + 2.833920419216156e-01*h1_ac_8 + 6.57121479511261e-01*h1_ac_9 + 4.568408131599426e-01*h1_ac_10 + 7.146657258272171e-02*h1_ac_11 + 3.483496904373169e-01*h1_ac_12 + 3.222237527370453e-01*h1_ac_13 + -1.0003118216991425e-01*h1_ac_14 + 3.500954210758209e-01*h1_ac_15 + 2.0234572887420654e-01;
    gi = 0.5*(h2_ac_23)*(1 + tanh(0.7978845608*((h2_ac_23) + 0.044715*(h2_ac_23)*(h2_ac_23)*(h2_ac_23)))); h2_ac_23 = gi;
    h2_ac_24 = -3.311202824115753e-01*h1_ac_0 + 4.701061248779297e-01*h1_ac_1 + -3.8141146302223206e-01*h1_ac_2 + 7.569734007120132e-02*h1_ac_3 + 6.71948492527008e-02*h1_ac_4 + 1.194339245557785e-01*h1_ac_5 + 2.085333615541458e-01*h1_ac_6 + -2.2318696975708008e-01*h1_ac_7 + 2.767486572265625e-01*h1_ac_8 + 3.705654442310333e-01*h1_ac_9 + -4.890480935573578e-01*h1_ac_10 + -4.9114376306533813e-01*h1_ac_11 + -3.317347764968872e-01*h1_ac_12 + -1.3750292360782623e-01*h1_ac_13 + -7.150296866893768e-02*h1_ac_14 + 2.5413116812705994e-01*h1_ac_15 + -1.6054607927799225e-01;
    gi = 0.5*(h2_ac_24)*(1 + tanh(0.7978845608*((h2_ac_24) + 0.044715*(h2_ac_24)*(h2_ac_24)*(h2_ac_24)))); h2_ac_24 = gi;
    h2_ac_25 = -1.0475657880306244e-01*h1_ac_0 + -9.159837663173676e-02*h1_ac_1 + 3.9747440814971924e-01*h1_ac_2 + 3.922653794288635e-01*h1_ac_3 + -4.535116255283356e-02*h1_ac_4 + -1.3852138817310333e-01*h1_ac_5 + -1.1251842975616455e-01*h1_ac_6 + -1.4707601070404053e-01*h1_ac_7 + -2.6271194219589233e-01*h1_ac_8 + 2.79283344745636e-01*h1_ac_9 + 6.367284804582596e-02*h1_ac_10 + 4.1388362646102905e-01*h1_ac_11 + 4.765683114528656e-01*h1_ac_12 + -8.950241655111313e-02*h1_ac_13 + 1.3105463981628418e-01*h1_ac_14 + -3.240041732788086e-01*h1_ac_15 + 2.101706713438034e-01;
    gi = 0.5*(h2_ac_25)*(1 + tanh(0.7978845608*((h2_ac_25) + 0.044715*(h2_ac_25)*(h2_ac_25)*(h2_ac_25)))); h2_ac_25 = gi;
    h2_ac_26 = -1.5199190378189087e-01*h1_ac_0 + 1.318446695804596e-01*h1_ac_1 + -5.823770761489868e-01*h1_ac_2 + 3.117949366569519e-01*h1_ac_3 + 9.244052320718765e-02*h1_ac_4 + -1.1777222156524658e+00*h1_ac_5 + 2.6260359212756157e-02*h1_ac_6 + -9.219543635845184e-02*h1_ac_7 + 5.137161538004875e-02*h1_ac_8 + 4.1164152324199677e-02*h1_ac_9 + -3.348437249660492e-01*h1_ac_10 + -5.796218514442444e-01*h1_ac_11 + 1.319960653781891e-01*h1_ac_12 + -2.4453946948051453e-01*h1_ac_13 + -5.395873636007309e-02*h1_ac_14 + 3.71711403131485e-01*h1_ac_15 + 2.6360180974006653e-01;
    gi = 0.5*(h2_ac_26)*(1 + tanh(0.7978845608*((h2_ac_26) + 0.044715*(h2_ac_26)*(h2_ac_26)*(h2_ac_26)))); h2_ac_26 = gi;
    h2_ac_27 = 5.466582179069519e-01*h1_ac_0 + 4.1711705923080444e-01*h1_ac_1 + -1.1099489778280258e-01*h1_ac_2 + 4.157825708389282e-01*h1_ac_3 + -9.91203561425209e-02*h1_ac_4 + -1.2135546654462814e-02*h1_ac_5 + -2.1376030147075653e-01*h1_ac_6 + 7.348282728344202e-03*h1_ac_7 + -3.108345866203308e-01*h1_ac_8 + 1.1579956859350204e-01*h1_ac_9 + 4.761393070220947e-01*h1_ac_10 + 4.400525987148285e-01*h1_ac_11 + -4.272150993347168e-01*h1_ac_12 + 2.7800101041793823e-01*h1_ac_13 + -4.965363144874573e-01*h1_ac_14 + -1.9877685606479645e-01*h1_ac_15 + 9.706500917673111e-02;
    gi = 0.5*(h2_ac_27)*(1 + tanh(0.7978845608*((h2_ac_27) + 0.044715*(h2_ac_27)*(h2_ac_27)*(h2_ac_27)))); h2_ac_27 = gi;
    h2_ac_28 = 2.884204089641571e-01*h1_ac_0 + -1.1280616745352745e-03*h1_ac_1 + 3.944432735443115e-01*h1_ac_2 + -4.410127103328705e-01*h1_ac_3 + 2.920759618282318e-01*h1_ac_4 + -6.825826317071915e-02*h1_ac_5 + -2.2831667959690094e-01*h1_ac_6 + 2.174540013074875e-01*h1_ac_7 + -6.737272143363953e-01*h1_ac_8 + -7.030214667320251e-01*h1_ac_9 + -3.7337014079093933e-01*h1_ac_10 + 1.1305329203605652e-01*h1_ac_11 + 3.0227547511458397e-02*h1_ac_12 + -2.580108344554901e-01*h1_ac_13 + -3.445322439074516e-02*h1_ac_14 + -5.131659507751465e-01*h1_ac_15 + 2.2070957720279694e-01;
    gi = 0.5*(h2_ac_28)*(1 + tanh(0.7978845608*((h2_ac_28) + 0.044715*(h2_ac_28)*(h2_ac_28)*(h2_ac_28)))); h2_ac_28 = gi;
    h2_ac_29 = -3.446996808052063e-01*h1_ac_0 + -2.828090488910675e-01*h1_ac_1 + -2.7695322036743164e-01*h1_ac_2 + 8.103685453534126e-03*h1_ac_3 + -2.1032018959522247e-01*h1_ac_4 + -6.027740836143494e-01*h1_ac_5 + -1.5033577382564545e-01*h1_ac_6 + 2.3325881361961365e-01*h1_ac_7 + 2.014779858291149e-02*h1_ac_8 + -3.264284133911133e-01*h1_ac_9 + 3.022170662879944e-01*h1_ac_10 + 3.8483890891075134e-01*h1_ac_11 + -6.322387456893921e-01*h1_ac_12 + 2.5443708896636963e-01*h1_ac_13 + -3.8469213247299194e-01*h1_ac_14 + -3.427157178521156e-02*h1_ac_15 + 1.1298912018537521e-01;
    gi = 0.5*(h2_ac_29)*(1 + tanh(0.7978845608*((h2_ac_29) + 0.044715*(h2_ac_29)*(h2_ac_29)*(h2_ac_29)))); h2_ac_29 = gi;
    h2_ac_30 = 6.848724484443665e-01*h1_ac_0 + 2.0577025413513184e-01*h1_ac_1 + 4.692281037569046e-02*h1_ac_2 + 4.303421452641487e-02*h1_ac_3 + 5.230874419212341e-01*h1_ac_4 + -7.632891535758972e-01*h1_ac_5 + -2.9058554768562317e-01*h1_ac_6 + 1.2161889672279358e-01*h1_ac_7 + -1.1429154872894287e-01*h1_ac_8 + -5.679369568824768e-01*h1_ac_9 + -4.946812093257904e-01*h1_ac_10 + -8.10961902141571e-01*h1_ac_11 + -1.2393211126327515e+00*h1_ac_12 + 8.32216203212738e-01*h1_ac_13 + -1.3088223338127136e-01*h1_ac_14 + 9.575169086456299e-01*h1_ac_15 + -4.837336540222168e-01;
    gi = 0.5*(h2_ac_30)*(1 + tanh(0.7978845608*((h2_ac_30) + 0.044715*(h2_ac_30)*(h2_ac_30)*(h2_ac_30)))); h2_ac_30 = gi;
    h2_ac_31 = -1.6533701121807098e-01*h1_ac_0 + -4.309285581111908e-01*h1_ac_1 + -1.351165920495987e-01*h1_ac_2 + 1.1507844924926758e-01*h1_ac_3 + -4.060122072696686e-01*h1_ac_4 + 1.416756510734558e-01*h1_ac_5 + 1.0707329213619232e-01*h1_ac_6 + 2.3102088272571564e-01*h1_ac_7 + 5.644813179969788e-01*h1_ac_8 + 4.8584872484207153e-01*h1_ac_9 + 4.610343277454376e-01*h1_ac_10 + -4.7146234661340714e-02*h1_ac_11 + -2.690735161304474e-01*h1_ac_12 + -2.762230634689331e-01*h1_ac_13 + 1.621195375919342e-01*h1_ac_14 + -3.53395938873291e-01*h1_ac_15 + -1.314793974161148e-01;
    gi = 0.5*(h2_ac_31)*(1 + tanh(0.7978845608*((h2_ac_31) + 0.044715*(h2_ac_31)*(h2_ac_31)*(h2_ac_31)))); h2_ac_31 = gi;
    h3_ac_0 = -2.0175422728061676e-01*h2_ac_0 + -9.43908542394638e-02*h2_ac_1 + -1.467123068869114e-02*h2_ac_2 + -1.2150217778980732e-02*h2_ac_3 + -1.522381454706192e-01*h2_ac_4 + -4.983972758054733e-02*h2_ac_5 + 4.079742431640625e-01*h2_ac_6 + 1.6778314486145973e-02*h2_ac_7 + 4.426294565200806e-02*h2_ac_8 + 1.336293388158083e-02*h2_ac_9 + 3.772253394126892e-01*h2_ac_10 + -1.8257886171340942e-01*h2_ac_11 + -2.0941871404647827e-01*h2_ac_12 + 3.363357186317444e-01*h2_ac_13 + 6.557632237672806e-03*h2_ac_14 + 7.255978882312775e-02*h2_ac_15 + -1.2297611683607101e-02*h2_ac_16 + -2.6722298935055733e-02*h2_ac_17 + 2.86213755607605e-01*h2_ac_18 + -6.565232574939728e-02*h2_ac_19 + -4.1068026423454285e-01*h2_ac_20 + -5.590639710426331e-01*h2_ac_21 + 2.918194979429245e-02*h2_ac_22 + 2.984717786312103e-01*h2_ac_23 + -5.021883249282837e-01*h2_ac_24 + -1.2219402939081192e-01*h2_ac_25 + 3.9866337180137634e-01*h2_ac_26 + -2.2087428718805313e-02*h2_ac_27 + -1.6654834151268005e-01*h2_ac_28 + -8.944912999868393e-02*h2_ac_29 + 1.6147298738360405e-02*h2_ac_30 + 3.6113981157541275e-02*h2_ac_31 + 8.242346346378326e-02;
    gi = 0.5*(h3_ac_0)*(1 + tanh(0.7978845608*((h3_ac_0) + 0.044715*(h3_ac_0)*(h3_ac_0)*(h3_ac_0)))); h3_ac_0 = gi;
    h3_ac_1 = -1.5942174196243286e-01*h2_ac_0 + 8.250907063484192e-02*h2_ac_1 + -2.5544190406799316e-01*h2_ac_2 + 1.0460403561592102e-01*h2_ac_3 + 1.3570083677768707e-01*h2_ac_4 + 3.7114568054676056e-02*h2_ac_5 + 6.759311258792877e-02*h2_ac_6 + -2.0992185175418854e-01*h2_ac_7 + -3.366437256336212e-01*h2_ac_8 + -1.5255244076251984e-01*h2_ac_9 + 2.104719579219818e-01*h2_ac_10 + 3.4845760464668274e-01*h2_ac_11 + -3.5765764117240906e-01*h2_ac_12 + -6.178468093276024e-02*h2_ac_13 + -1.8806660175323486e-01*h2_ac_14 + 3.662029281258583e-02*h2_ac_15 + -2.60059405118227e-02*h2_ac_16 + -1.554688811302185e-01*h2_ac_17 + -2.612834982573986e-02*h2_ac_18 + 1.2981520965695381e-02*h2_ac_19 + -2.6637276634573936e-02*h2_ac_20 + -1.987997144460678e-01*h2_ac_21 + 8.391530811786652e-02*h2_ac_22 + 4.346347749233246e-01*h2_ac_23 + -2.3690198361873627e-01*h2_ac_24 + -3.135807067155838e-02*h2_ac_25 + 4.230620563030243e-01*h2_ac_26 + 2.5683411955833435e-01*h2_ac_27 + -3.201506435871124e-01*h2_ac_28 + -2.9563677310943604e-01*h2_ac_29 + -3.837231993675232e-01*h2_ac_30 + 3.718131482601166e-01*h2_ac_31 + 1.1899279803037643e-01;
    gi = 0.5*(h3_ac_1)*(1 + tanh(0.7978845608*((h3_ac_1) + 0.044715*(h3_ac_1)*(h3_ac_1)*(h3_ac_1)))); h3_ac_1 = gi;
    h3_ac_2 = -1.1815842241048813e-01*h2_ac_0 + -2.601572275161743e-01*h2_ac_1 + -2.055550180375576e-02*h2_ac_2 + -8.479713648557663e-02*h2_ac_3 + 1.2482768297195435e-01*h2_ac_4 + -3.5596445202827454e-01*h2_ac_5 + 2.7977654337882996e-01*h2_ac_6 + -5.23159921169281e-01*h2_ac_7 + -4.65102881193161e-01*h2_ac_8 + 1.627350151538849e-01*h2_ac_9 + -4.748157039284706e-02*h2_ac_10 + -2.5341105461120605e-01*h2_ac_11 + -5.1300909370183945e-02*h2_ac_12 + -8.940108120441437e-02*h2_ac_13 + 3.5812079906463623e-01*h2_ac_14 + 9.135545790195465e-02*h2_ac_15 + 1.6867049038410187e-01*h2_ac_16 + -2.1886935830116272e-01*h2_ac_17 + -1.3257502019405365e-01*h2_ac_18 + -1.5325595438480377e-01*h2_ac_19 + -7.51694917678833e-01*h2_ac_20 + 9.173061698675156e-02*h2_ac_21 + 4.0474939346313477e-01*h2_ac_22 + -3.2064759731292725e-01*h2_ac_23 + 4.012187421321869e-01*h2_ac_24 + -3.5111263394355774e-01*h2_ac_25 + 1.7247997224330902e-01*h2_ac_26 + -1.225375309586525e-01*h2_ac_27 + 1.7740577459335327e-01*h2_ac_28 + -1.6066356003284454e-01*h2_ac_29 + 7.128163706511259e-03*h2_ac_30 + -2.639031410217285e-01*h2_ac_31 + -1.8015192821621895e-02;
    gi = 0.5*(h3_ac_2)*(1 + tanh(0.7978845608*((h3_ac_2) + 0.044715*(h3_ac_2)*(h3_ac_2)*(h3_ac_2)))); h3_ac_2 = gi;
    h3_ac_3 = 1.1343088001012802e-01*h2_ac_0 + 6.721504032611847e-02*h2_ac_1 + -3.517436981201172e-02*h2_ac_2 + -2.769906520843506e-01*h2_ac_3 + -1.331157684326172e-01*h2_ac_4 + -2.874683439731598e-01*h2_ac_5 + -4.508981853723526e-02*h2_ac_6 + 1.3199181854724884e-01*h2_ac_7 + -1.588941067457199e-01*h2_ac_8 + 2.2566646803170443e-03*h2_ac_9 + -3.537007421255112e-02*h2_ac_10 + -1.715921312570572e-01*h2_ac_11 + 3.770832419395447e-01*h2_ac_12 + -7.692733407020569e-02*h2_ac_13 + 1.1379207670688629e-01*h2_ac_14 + -3.2828450202941895e-02*h2_ac_15 + -5.744082108139992e-02*h2_ac_16 + 8.919958770275116e-02*h2_ac_17 + -7.860686630010605e-03*h2_ac_18 + 1.1797023005783558e-02*h2_ac_19 + -1.8007653998211026e-03*h2_ac_20 + 2.836854159832001e-01*h2_ac_21 + 1.2252657860517502e-01*h2_ac_22 + -3.413538932800293e-01*h2_ac_23 + 1.6047300398349762e-01*h2_ac_24 + -1.940605603158474e-02*h2_ac_25 + -2.966465353965759e-01*h2_ac_26 + -1.7319521307945251e-01*h2_ac_27 + -1.5599027276039124e-01*h2_ac_28 + 1.948181539773941e-01*h2_ac_29 + -1.0514430701732635e-01*h2_ac_30 + 8.774509280920029e-02*h2_ac_31 + -3.922822177410126e-01;
    gi = 0.5*(h3_ac_3)*(1 + tanh(0.7978845608*((h3_ac_3) + 0.044715*(h3_ac_3)*(h3_ac_3)*(h3_ac_3)))); h3_ac_3 = gi;
    h3_ac_4 = -2.1999351680278778e-01*h2_ac_0 + 1.5503396093845367e-01*h2_ac_1 + 9.524116665124893e-02*h2_ac_2 + -3.2957518100738525e-01*h2_ac_3 + -2.364296279847622e-02*h2_ac_4 + 1.338246837258339e-02*h2_ac_5 + -1.9590334594249725e-01*h2_ac_6 + -1.0167354345321655e-01*h2_ac_7 + -2.4978093802928925e-01*h2_ac_8 + 5.262954831123352e-01*h2_ac_9 + 1.8069522082805634e-01*h2_ac_10 + 2.6911062002182007e-01*h2_ac_11 + -6.607981026172638e-02*h2_ac_12 + -3.7966588139533997e-01*h2_ac_13 + -2.1775799989700317e-01*h2_ac_14 + -1.391313523054123e-01*h2_ac_15 + 2.837059795856476e-01*h2_ac_16 + -2.3447155952453613e-02*h2_ac_17 + 1.7305156216025352e-02*h2_ac_18 + 2.81819611787796e-01*h2_ac_19 + -1.7881445586681366e-01*h2_ac_20 + 2.3129069805145264e-01*h2_ac_21 + 5.235709249973297e-02*h2_ac_22 + -1.0358123481273651e-01*h2_ac_23 + -1.8838362395763397e-01*h2_ac_24 + -1.6138309240341187e-01*h2_ac_25 + 2.918301522731781e-01*h2_ac_26 + 1.9408169388771057e-01*h2_ac_27 + -2.8699761629104614e-01*h2_ac_28 + -1.993907392024994e-01*h2_ac_29 + -3.0611908435821533e-01*h2_ac_30 + 3.520141839981079e-01*h2_ac_31 + 5.789487063884735e-02;
    gi = 0.5*(h3_ac_4)*(1 + tanh(0.7978845608*((h3_ac_4) + 0.044715*(h3_ac_4)*(h3_ac_4)*(h3_ac_4)))); h3_ac_4 = gi;
    h3_ac_5 = 3.6571693420410156e-01*h2_ac_0 + 1.4551228284835815e-01*h2_ac_1 + 1.4669077098369598e-01*h2_ac_2 + 2.88941890001297e-01*h2_ac_3 + -2.034284621477127e-01*h2_ac_4 + 2.5034254789352417e-01*h2_ac_5 + 1.4038872718811035e-01*h2_ac_6 + -3.1784337759017944e-01*h2_ac_7 + 2.1042531356215477e-02*h2_ac_8 + -6.094310060143471e-02*h2_ac_9 + -3.930099904537201e-01*h2_ac_10 + 3.1130945682525635e-01*h2_ac_11 + 3.539351224899292e-01*h2_ac_12 + 3.3037376403808594e-01*h2_ac_13 + -1.1062224954366684e-01*h2_ac_14 + -1.7303670942783356e-01*h2_ac_15 + -1.0059019178152084e-01*h2_ac_16 + 1.9718384742736816e-01*h2_ac_17 + -3.071010112762451e-01*h2_ac_18 + 1.463121771812439e-01*h2_ac_19 + 3.2375749945640564e-01*h2_ac_20 + 1.5670007467269897e-01*h2_ac_21 + -2.3524412512779236e-01*h2_ac_22 + 1.3563548028469086e-01*h2_ac_23 + 1.4368022978305817e-01*h2_ac_24 + 3.0103962868452072e-02*h2_ac_25 + -1.8505153059959412e-01*h2_ac_26 + -2.1198001503944397e-01*h2_ac_27 + 2.9008927941322327e-01*h2_ac_28 + -1.9129982590675354e-01*h2_ac_29 + 8.567579090595245e-02*h2_ac_30 + 9.40375104546547e-02*h2_ac_31 + 5.920067057013512e-02;
    gi = 0.5*(h3_ac_5)*(1 + tanh(0.7978845608*((h3_ac_5) + 0.044715*(h3_ac_5)*(h3_ac_5)*(h3_ac_5)))); h3_ac_5 = gi;
    h3_ac_6 = -3.665290027856827e-02*h2_ac_0 + -2.1748855710029602e-01*h2_ac_1 + -9.730979055166245e-02*h2_ac_2 + 3.6039117723703384e-02*h2_ac_3 + 2.840007245540619e-01*h2_ac_4 + 1.1738663166761398e-01*h2_ac_5 + 6.13785982131958e-02*h2_ac_6 + 6.348633766174316e-02*h2_ac_7 + 2.5460943579673767e-01*h2_ac_8 + 9.634704142808914e-02*h2_ac_9 + -5.0697922706604e-01*h2_ac_10 + 8.950374275445938e-02*h2_ac_11 + -2.367304265499115e-01*h2_ac_12 + -6.827200204133987e-02*h2_ac_13 + -3.6256057024002075e-01*h2_ac_14 + 1.3893289864063263e-01*h2_ac_15 + 9.541354328393936e-02*h2_ac_16 + -8.156149089336395e-02*h2_ac_17 + 2.806755006313324e-01*h2_ac_18 + 2.5924164056777954e-01*h2_ac_19 + 7.064329832792282e-02*h2_ac_20 + -1.8047119677066803e-01*h2_ac_21 + -1.259327083826065e-01*h2_ac_22 + -7.009352743625641e-02*h2_ac_23 + -1.377309262752533e-01*h2_ac_24 + -4.878678023815155e-01*h2_ac_25 + 1.1687523871660233e-01*h2_ac_26 + -3.0139610171318054e-01*h2_ac_27 + 5.357256531715393e-02*h2_ac_28 + -4.206917881965637e-01*h2_ac_29 + -1.8521231831982732e-03*h2_ac_30 + -2.0208388566970825e-01*h2_ac_31 + 4.5892721973359585e-03;
    gi = 0.5*(h3_ac_6)*(1 + tanh(0.7978845608*((h3_ac_6) + 0.044715*(h3_ac_6)*(h3_ac_6)*(h3_ac_6)))); h3_ac_6 = gi;
    h3_ac_7 = 1.4161570370197296e-01*h2_ac_0 + 1.708354353904724e-01*h2_ac_1 + 2.8550803661346436e-01*h2_ac_2 + 1.9357052445411682e-01*h2_ac_3 + 2.6695793867111206e-01*h2_ac_4 + 6.438811123371124e-02*h2_ac_5 + 1.0396673530340195e-01*h2_ac_6 + 3.7337273359298706e-01*h2_ac_7 + -4.950297623872757e-02*h2_ac_8 + -4.1717424988746643e-01*h2_ac_9 + -1.6740162670612335e-01*h2_ac_10 + 2.989070415496826e-01*h2_ac_11 + -2.0051857829093933e-01*h2_ac_12 + 2.992885187268257e-03*h2_ac_13 + -2.1164359152317047e-01*h2_ac_14 + -2.731062173843384e-01*h2_ac_15 + 3.3144107460975647e-01*h2_ac_16 + 1.1429060995578766e-01*h2_ac_17 + -8.050437271595001e-02*h2_ac_18 + 2.2410951554775238e-01*h2_ac_19 + 2.7253293991088867e-01*h2_ac_20 + -5.625203251838684e-02*h2_ac_21 + -2.4418382346630096e-01*h2_ac_22 + -1.370132714509964e-01*h2_ac_23 + 2.50962283462286e-02*h2_ac_24 + 3.5207054018974304e-01*h2_ac_25 + 1.1341627687215805e-01*h2_ac_26 + 1.3126008212566376e-01*h2_ac_27 + 3.4209340810775757e-01*h2_ac_28 + -1.9910500943660736e-01*h2_ac_29 + -7.482237368822098e-02*h2_ac_30 + 3.341858983039856e-01*h2_ac_31 + 2.054540514945984e-01;
    gi = 0.5*(h3_ac_7)*(1 + tanh(0.7978845608*((h3_ac_7) + 0.044715*(h3_ac_7)*(h3_ac_7)*(h3_ac_7)))); h3_ac_7 = gi;
    y0_ac = -5.6470341980457306e-02*h3_ac_0 + 9.022407531738281e-01*h3_ac_1 + -7.96687126159668e-01*h3_ac_2 + -3.7827470898628235e-01*h3_ac_3 + 6.226081848144531e-01*h3_ac_4 + -5.4852262139320374e-02*h3_ac_5 + 7.247819900512695e-01*h3_ac_6 + -6.037130951881409e-01*h3_ac_7 + 1.803591102361679e-02;
    y1_ac = 1.1777849197387695e+00*h3_ac_0 + 1.2155945599079132e-01*h3_ac_1 + -1.9936461001634598e-02*h3_ac_2 + -8.771542310714722e-01*h3_ac_3 + -1.7427535355091095e-01*h3_ac_4 + -6.026567220687866e-01*h3_ac_5 + -8.050940036773682e-01*h3_ac_6 + -2.56865531206131e-01*h3_ac_7 + 1.1442435532808304e-01;
    y2_ac = 3.700360357761383e-01*h3_ac_0 + 6.479097604751587e-01*h3_ac_1 + -4.2719945311546326e-01*h3_ac_2 + 3.2554176449775696e-01*h3_ac_3 + 1.4171797037124634e-01*h3_ac_4 + -2.7914512157440186e-01*h3_ac_5 + 8.886103332042694e-02*h3_ac_6 + -4.9908727407455444e-01*h3_ac_7 + 2.503841519355774e-01;
    Cgs = y0_ac * 5.0491600187853786e-17 + 1.0019975730256627e-16;
    Cgd = y1_ac * 4.154897699925873e-17 + 7.278805643923555e-17;
    Cgg = y2_ac * 8.94379652359691e-17 + 1.7298736704439973e-16;
    if (Cgs < 1e-30) Cgs = 1e-30;
    if (Cgd < 1e-30) Cgd = 1e-30;
    // I = dQ/dt (charge-conserving); Q_gs = Cgs*V(g,s), Q_gd = Cgd*V(g,d)
    I(g,s) <+ ddt(Cgs * V(g,s));
    I(g,d) <+ ddt(Cgd * V(g,d));
    // Output Cgs,Cgd,Cgg in F (SI) for HSPICE .print; plot script converts F->fF
    V(cgs_out) <+ Cgs;
    V(cgd_out) <+ Cgd;
    V(cgg_out) <+ Cgg;
  end
endmodule
